* NGSPICE file created from opamp.ext - technology: sky130A

.subckt opamp Vref Vout Vp Vn VDD GND
X0 Vd24.t9 Vd24.t8 a_40258_n12.t2 GND.t12 sky130_fd_pr__nfet_g5v0d10v5 ad=0.725 pd=5.29 as=1.45 ps=10.58 w=5 l=0.5
X1 GND.t11 Vg28.t39 Vout GND.t25 sky130_fd_pr__nfet_g5v0d10v5 ad=1.45 pd=10.29 as=1.45 ps=10.29 w=10 l=0.5
X2 a_40258_n12.t8 a_40258_n12.t7 GND.t5 GND.t17 sky130_fd_pr__nfet_g5v0d10v5 ad=0.725 pd=5.29 as=0.725 ps=5.29 w=5 l=0.5
X3 Vd10 Vg1 GND.t44 GND.t43 sky130_fd_pr__nfet_g5v0d10v5 ad=2.9 pd=20.58 as=2.9 ps=20.58 w=10 l=5
X4 Vd9 Vg1 Vg28.t21 GND.t39 sky130_fd_pr__nfet_g5v0d10v5 ad=2.0735 pd=14.59 as=2.0735 ps=14.59 w=14.3 l=2
X5 Vd8.t11 Vg5.t8 a_26297_13170# VDD.t30 sky130_fd_pr__pfet_g5v0d10v5 ad=1.914 pd=13.49 as=1.914 ps=13.49 w=13.2 l=2
X6 Vout Vg28.t32 GND.t11 GND.t33 sky130_fd_pr__nfet_g5v0d10v5 ad=1.45 pd=10.29 as=1.45 ps=10.29 w=10 l=0.5
X7 Vg28.t20 Vg1 Vd9 GND.t39 sky130_fd_pr__nfet_g5v0d10v5 ad=4.147 pd=29.18 as=2.0735 ps=14.59 w=14.3 l=2
X8 Vout Vg28.t38 GND.t11 GND.t23 sky130_fd_pr__nfet_g5v0d10v5 ad=1.45 pd=10.29 as=1.45 ps=10.29 w=10 l=0.5
X9 Vs29 Vp.t5 Vd29 GND.t2 sky130_fd_pr__nfet_g5v0d10v5 ad=1.61095 pd=11.4 as=1.61095 ps=11.4 w=11.11 l=1.5
X10 m01_02.sky130_fd_pr__nfet_g5v0d10v5_Y3KDPX_0.D Vg1 Vg1 GND.t35 sky130_fd_pr__nfet_g5v0d10v5 ad=0.48285 pd=3.62 as=0.48285 ps=3.62 w=3.33 l=2
X11 Vg11.t7 Vg11.t6 Vd30 VDD.t7 sky130_fd_pr__pfet_g5v0d10v5 ad=1.45 pd=10.29 as=1.45 ps=10.29 w=10 l=1
X12 Vs29 Vg1 a_27266_764# GND.t37 sky130_fd_pr__nfet_g5v0d10v5 ad=1.9314 pd=13.9 as=0.9657 ps=6.95 w=6.66 l=2
X13 VgR2 Vref GND.t1 GND.t0 sky130_fd_pr__nfet_g5v0d10v5 ad=1.45 pd=10.58 as=1.45 ps=10.58 w=5 l=8
X14 a_23419_13228# Vg5.t14 VDD.t54 VDD.t24 sky130_fd_pr__pfet_g5v0d10v5 ad=0.725 pd=5.29 as=0.725 ps=5.29 w=5 l=5
X15 Vd29 Vg11.t19 Vg27.t0 VDD.t4 sky130_fd_pr__pfet_g5v0d10v5 ad=1.45 pd=10.29 as=1.45 ps=10.29 w=10 l=1
X16 Vg5.t6 Vg1 M03_04.sky130_fd_pr__nfet_g5v0d10v5_Y3KDPX_0.D GND.t36 sky130_fd_pr__nfet_g5v0d10v5 ad=0.48285 pd=3.62 as=0.9657 ps=7.24 w=3.33 l=2
X17 GND.t5 a_40258_n12.t9 a_40258_n12.t10 GND.t13 sky130_fd_pr__nfet_g5v0d10v5 ad=0.725 pd=5.29 as=0.725 ps=5.29 w=5 l=0.5
X18 VDD.t40 Vg27.t46 Vout VDD.t39 sky130_fd_pr__pfet_g5v0d10v5 ad=2.175 pd=15.29 as=2.175 ps=15.29 w=15 l=0.5
X19 VDD.t71 Vg11.t27 Vd30 VDD.t7 sky130_fd_pr__pfet_g5v0d10v5 ad=1.45 pd=10.29 as=2.9 ps=20.58 w=10 l=2.5
X20 Vg1 Vg1 m01_02.sky130_fd_pr__nfet_g5v0d10v5_Y3KDPX_0.D GND.t35 sky130_fd_pr__nfet_g5v0d10v5 ad=0.9657 pd=7.24 as=0.48285 ps=3.62 w=3.33 l=2
X21 GND.t11 Vg28.t41 Vout GND.t24 sky130_fd_pr__nfet_g5v0d10v5 ad=1.45 pd=10.29 as=1.45 ps=10.29 w=10 l=0.5
X22 a_40258_n12.t4 a_40258_n12.t3 GND.t5 GND.t16 sky130_fd_pr__nfet_g5v0d10v5 ad=1.45 pd=10.58 as=0.725 ps=5.29 w=5 l=0.5
X23 Vout Vg28.t34 GND.t11 GND.t20 sky130_fd_pr__nfet_g5v0d10v5 ad=1.45 pd=10.29 as=1.45 ps=10.29 w=10 l=0.5
X24 Vout Vg27.t49 VDD.t86 VDD.t85 sky130_fd_pr__pfet_g5v0d10v5 ad=2.175 pd=15.29 as=2.175 ps=15.29 w=15 l=0.5
X25 Vg27.t25 Vout.t2 sky130_fd_pr__cap_mim_m3_1 l=20 w=30
X26 VDD.t25 Vg5.t13 a_23419_13228# VDD.t24 sky130_fd_pr__pfet_g5v0d10v5 ad=0.725 pd=5.29 as=1.45 ps=10.58 w=5 l=5
X27 Vd30 Vn.t0 Vs29 GND.t14 sky130_fd_pr__nfet_g5v0d10v5 ad=1.61095 pd=11.4 as=3.2219 ps=22.8 w=11.11 l=1.5
X28 Vd8.t14 Vn.t17 Vd10 Vd8.t13 sky130_fd_pr__pfet_g5v0d10v5 ad=6.4438 pd=45.02 as=3.2219 ps=22.51 w=22.22 l=1.5
X29 Vg22.t10 Vg1 GND.t41 GND.t40 sky130_fd_pr__nfet_g5v0d10v5 ad=0.435 pd=3.58 as=0.435 ps=3.58 w=1.5 l=5
X30 Vout Vg28.t30 GND.t11 GND.t10 sky130_fd_pr__nfet_g5v0d10v5 ad=1.45 pd=10.29 as=1.45 ps=10.29 w=10 l=0.5
X31 Vd10 Vn.t12 Vd8.t19 Vd8.t13 sky130_fd_pr__pfet_g5v0d10v5 ad=3.2219 pd=22.51 as=3.2219 ps=22.51 w=22.22 l=1.5
X32 M03_04.sky130_fd_pr__nfet_g5v0d10v5_Y3KDPX_0.D Vg1 GND.t47 GND.t36 sky130_fd_pr__nfet_g5v0d10v5 ad=1.45 pd=10.58 as=1.45 ps=10.58 w=5 l=5
X33 Vout Vg28.t40 GND.t11 GND.t26 sky130_fd_pr__nfet_g5v0d10v5 ad=1.45 pd=10.29 as=1.45 ps=10.29 w=10 l=0.5
X34 Vd30 Vn.t8 Vs29 GND.t14 sky130_fd_pr__nfet_g5v0d10v5 ad=3.2219 pd=22.8 as=1.61095 ps=11.4 w=11.11 l=1.5
X35 GND.t5 a_40258_n12.t5 a_40258_n12.t6 GND.t50 sky130_fd_pr__nfet_g5v0d10v5 ad=0.725 pd=5.29 as=0.725 ps=5.29 w=5 l=0.5
X36 GND.t11 Vg28.t33 Vout GND.t15 sky130_fd_pr__nfet_g5v0d10v5 ad=1.45 pd=10.29 as=1.45 ps=10.29 w=10 l=0.5
X37 VDD.t44 Vg27.t48 Vout VDD.t43 sky130_fd_pr__pfet_g5v0d10v5 ad=2.175 pd=15.29 as=2.175 ps=15.29 w=15 l=0.5
X38 Vd30 Vg11.t8 Vg11.t9 VDD.t7 sky130_fd_pr__pfet_g5v0d10v5 ad=1.45 pd=10.29 as=2.9 ps=20.58 w=10 l=1
X39 Vout Vg27.t41 VDD.t34 VDD.t33 sky130_fd_pr__pfet_g5v0d10v5 ad=2.175 pd=15.29 as=2.175 ps=15.29 w=15 l=0.5
X40 Vg28.t27 Vout.t6 sky130_fd_pr__cap_mim_m3_1 l=20 w=30
X41 Vd30 Vg11.t30 VDD.t74 VDD.t7 sky130_fd_pr__pfet_g5v0d10v5 ad=1.45 pd=10.29 as=1.45 ps=10.29 w=10 l=2.5
X42 Vout Vg28.t36 GND.t11 GND.t19 sky130_fd_pr__nfet_g5v0d10v5 ad=1.45 pd=10.29 as=1.45 ps=10.29 w=10 l=0.5
X43 Vd29 Vg11.t23 VDD.t68 VDD.t4 sky130_fd_pr__pfet_g5v0d10v5 ad=1.45 pd=10.29 as=1.45 ps=10.29 w=10 l=2.5
X44 GND.t11 Vg28.t29 Vout GND.t30 sky130_fd_pr__nfet_g5v0d10v5 ad=1.45 pd=10.29 as=1.45 ps=10.29 w=10 l=0.5
X45 VDD.t19 Vg27.t44 Vout VDD.t18 sky130_fd_pr__pfet_g5v0d10v5 ad=2.175 pd=15.29 as=2.175 ps=15.29 w=15 l=0.5
X46 VDD.t73 Vg11.t29 Vd30 VDD.t7 sky130_fd_pr__pfet_g5v0d10v5 ad=1.45 pd=10.29 as=1.45 ps=10.29 w=10 l=2.5
X47 Vd29 Vp.t0 Vs29 GND.t2 sky130_fd_pr__nfet_g5v0d10v5 ad=1.61095 pd=11.4 as=3.2219 ps=22.8 w=11.11 l=1.5
X48 Vd9 Vg1 GND.t49 GND.t48 sky130_fd_pr__nfet_g5v0d10v5 ad=2.9 pd=20.58 as=2.9 ps=20.58 w=10 l=5
X49 Vd8.t16 Vn.t15 Vd10 Vd8.t13 sky130_fd_pr__pfet_g5v0d10v5 ad=3.2219 pd=22.51 as=3.2219 ps=22.51 w=22.22 l=1.5
X50 Vd10 Vn.t10 Vd8.t21 Vd8.t13 sky130_fd_pr__pfet_g5v0d10v5 ad=3.2219 pd=22.51 as=3.2219 ps=22.51 w=22.22 l=1.5
X51 Vout Vg27.t47 VDD.t36 VDD.t35 sky130_fd_pr__pfet_g5v0d10v5 ad=2.175 pd=15.29 as=2.175 ps=15.29 w=15 l=0.5
X52 a_26297_13170# Vg5.t7 Vd8.t12 VDD.t30 sky130_fd_pr__pfet_g5v0d10v5 ad=1.914 pd=13.49 as=3.828 ps=26.98 w=13.2 l=2
X53 a_26297_13170# Vg5.t9 Vd8.t10 VDD.t30 sky130_fd_pr__pfet_g5v0d10v5 ad=3.828 pd=26.98 as=1.914 ps=13.49 w=13.2 l=2
X54 Vd29 Vp.t8 Vs29 GND.t2 sky130_fd_pr__nfet_g5v0d10v5 ad=3.2219 pd=22.8 as=1.61095 ps=11.4 w=11.11 l=1.5
X55 Vout Vg27.t37 VDD.t83 VDD.t82 sky130_fd_pr__pfet_g5v0d10v5 ad=2.175 pd=15.29 as=2.175 ps=15.29 w=15 l=0.5
X56 VDD.t94 Vg27.t50 Vout VDD.t93 sky130_fd_pr__pfet_g5v0d10v5 ad=4.35 pd=30.58 as=2.175 ps=15.29 w=15 l=0.5
X57 Vd8.t9 Vp.t9 Vd9 Vd8.t0 sky130_fd_pr__pfet_g5v0d10v5 ad=3.2219 pd=22.51 as=6.4438 ps=45.02 w=22.22 l=1.5
X58 GND.t11 Vg28.t35 Vout GND.t21 sky130_fd_pr__nfet_g5v0d10v5 ad=1.45 pd=10.29 as=1.45 ps=10.29 w=10 l=0.5
X59 Vout Vg28.t28 GND.t11 GND.t29 sky130_fd_pr__nfet_g5v0d10v5 ad=1.45 pd=10.29 as=2.9 ps=20.58 w=10 l=0.5
X60 Vout Vg27.t43 VDD.t66 VDD.t65 sky130_fd_pr__pfet_g5v0d10v5 ad=2.175 pd=15.29 as=2.175 ps=15.29 w=15 l=0.5
X61 Vd29 Vg11.t21 Vg27.t23 VDD.t4 sky130_fd_pr__pfet_g5v0d10v5 ad=2.9 pd=20.58 as=1.45 ps=10.29 w=10 l=1
X62 VDD.t70 Vg11.t26 Vd29 VDD.t4 sky130_fd_pr__pfet_g5v0d10v5 ad=2.9 pd=20.58 as=1.45 ps=10.29 w=10 l=2.5
X63 Vd30 Vn.t6 Vs29 GND.t14 sky130_fd_pr__nfet_g5v0d10v5 ad=1.61095 pd=11.4 as=1.61095 ps=11.4 w=11.11 l=1.5
X64 M03_04.sky130_fd_pr__nfet_g5v0d10v5_Y3KDPX_0.D Vg1 Vg5.t5 GND.t36 sky130_fd_pr__nfet_g5v0d10v5 ad=0.48285 pd=3.62 as=0.48285 ps=3.62 w=3.33 l=2
X65 GND.t11 Vg28.t31 Vout GND.t18 sky130_fd_pr__nfet_g5v0d10v5 ad=1.45 pd=10.29 as=1.45 ps=10.29 w=10 l=0.5
X66 VDD.t89 Vg27.t36 Vout VDD.t88 sky130_fd_pr__pfet_g5v0d10v5 ad=2.175 pd=15.29 as=2.175 ps=15.29 w=15 l=0.5
X67 VDD.t42 Vg27.t42 Vout VDD.t41 sky130_fd_pr__pfet_g5v0d10v5 ad=2.175 pd=15.29 as=2.175 ps=15.29 w=15 l=0.5
X68 Vg5.t4 Vg1 M03_04.sky130_fd_pr__nfet_g5v0d10v5_Y3KDPX_0.D GND.t36 sky130_fd_pr__nfet_g5v0d10v5 ad=0.9657 pd=7.24 as=0.48285 ps=3.62 w=3.33 l=2
X69 Vs29 Vn.t3 Vd30 GND.t14 sky130_fd_pr__nfet_g5v0d10v5 ad=1.61095 pd=11.4 as=1.61095 ps=11.4 w=11.11 l=1.5
X70 VDD.t9 Vg27.t32 Vout VDD.t8 sky130_fd_pr__pfet_g5v0d10v5 ad=2.175 pd=15.29 as=2.175 ps=15.29 w=15 l=0.5
X71 Vg27.t24 Vg11.t20 Vd29 VDD.t4 sky130_fd_pr__pfet_g5v0d10v5 ad=1.45 pd=10.29 as=1.45 ps=10.29 w=10 l=1
X72 Vout Vg27.t39 VDD.t17 VDD.t16 sky130_fd_pr__pfet_g5v0d10v5 ad=2.175 pd=15.29 as=2.175 ps=15.29 w=15 l=0.5
X73 Vd29 Vp.t6 Vs29 GND.t2 sky130_fd_pr__nfet_g5v0d10v5 ad=1.61095 pd=11.4 as=1.61095 ps=11.4 w=11.11 l=1.5
X74 Vout Vg27.t45 VDD.t80 VDD.t79 sky130_fd_pr__pfet_g5v0d10v5 ad=2.175 pd=15.29 as=2.175 ps=15.29 w=15 l=0.5
X75 Vg28.t27 Vout.t6 sky130_fd_pr__cap_mim_m3_1 l=20 w=30
X76 Vd9 Vp.t14 Vd8.t4 Vd8.t0 sky130_fd_pr__pfet_g5v0d10v5 ad=3.2219 pd=22.51 as=3.2219 ps=22.51 w=22.22 l=1.5
X77 a_23419_13228# Vg5.t3 Vg5 VDD.t10 sky130_fd_pr__pfet_g5v0d10v5 ad=0.957 pd=6.89 as=1.914 ps=13.78 w=6.6 l=2
X78 Vg27.t3 Vg22.t25 Vg28.t14 VDD.t101 sky130_fd_pr__pfet_g5v0d10v5 ad=2.9 pd=20.58 as=1.45 ps=10.29 w=10 l=0.5
X79 VDD.t64 Vg27.t38 Vout VDD.t63 sky130_fd_pr__pfet_g5v0d10v5 ad=2.175 pd=15.29 as=2.175 ps=15.29 w=15 l=0.5
X80 Vg27.t2 Vg11.t18 Vd29 VDD.t4 sky130_fd_pr__pfet_g5v0d10v5 ad=1.45 pd=10.29 as=1.45 ps=10.29 w=10 l=1
X81 Vout Vg27.t31 VDD.t27 VDD.t26 sky130_fd_pr__pfet_g5v0d10v5 ad=2.175 pd=15.29 as=2.175 ps=15.29 w=15 l=0.5
X82 Vg22.t7 Vg22.t6 m21_22_0.G VDD.t46 sky130_fd_pr__pfet_g5v0d10v5 ad=2.175 pd=15.29 as=2.175 ps=15.29 w=15 l=0.5
X83 Vd9 Vp.t12 Vd8.t6 Vd8.t0 sky130_fd_pr__pfet_g5v0d10v5 ad=3.2219 pd=22.51 as=3.2219 ps=22.51 w=22.22 l=1.5
X84 VDD.t52 VgR2 Vg1 VDD.t51 sky130_fd_pr__pfet_g5v0d10v5 ad=1.16 pd=8.58 as=1.16 ps=8.58 w=4 l=5
X85 Vs29 Vn.t1 Vd30 GND.t14 sky130_fd_pr__nfet_g5v0d10v5 ad=1.61095 pd=11.4 as=1.61095 ps=11.4 w=11.11 l=1.5
X86 Vs29 Vp.t3 Vd29 GND.t2 sky130_fd_pr__nfet_g5v0d10v5 ad=1.61095 pd=11.4 as=1.61095 ps=11.4 w=11.11 l=1.5
X87 VDD.t90 Vg11.t22 Vd29 VDD.t4 sky130_fd_pr__pfet_g5v0d10v5 ad=1.45 pd=10.29 as=2.9 ps=20.58 w=10 l=2.5
X88 m21_22_0.G Vg22.t0 Vg22.t1 VDD.t13 sky130_fd_pr__pfet_g5v0d10v5 ad=4.35 pd=30.58 as=2.175 ps=15.29 w=15 l=0.5
X89 Vd8.t18 Vn.t13 Vd10 Vd8.t13 sky130_fd_pr__pfet_g5v0d10v5 ad=3.2219 pd=22.51 as=3.2219 ps=22.51 w=22.22 l=1.5
X90 Vg27.t18 Vd24.t14 Vg28.t11 GND.t28 sky130_fd_pr__nfet_g5v0d10v5 ad=2.9 pd=20.58 as=1.45 ps=10.29 w=10 l=0.5
X91 VDD.t107 Vg5.t15 a_23419_13228# VDD.t24 sky130_fd_pr__pfet_g5v0d10v5 ad=1.45 pd=10.58 as=0.725 ps=5.29 w=5 l=5
X92 Vg28.t13 Vg22.t24 Vg27.t4 VDD.t100 sky130_fd_pr__pfet_g5v0d10v5 ad=1.45 pd=10.29 as=1.45 ps=10.29 w=10 l=0.5
X93 m21_22_0.G Vg22.t8 Vg22.t9 VDD.t20 sky130_fd_pr__pfet_g5v0d10v5 ad=2.175 pd=15.29 as=4.35 ps=30.58 w=15 l=0.5
X94 a_40258_n12.t12 a_40258_n12.t11 GND.t5 GND.t4 sky130_fd_pr__nfet_g5v0d10v5 ad=0.725 pd=5.29 as=1.45 ps=10.58 w=5 l=0.5
X95 VDD.t62 Vg27.t34 Vout VDD.t61 sky130_fd_pr__pfet_g5v0d10v5 ad=2.175 pd=15.29 as=2.175 ps=15.29 w=15 l=0.5
X96 Vd9 Vp.t10 Vd8.t8 Vd8.t0 sky130_fd_pr__pfet_g5v0d10v5 ad=3.2219 pd=22.51 as=3.2219 ps=22.51 w=22.22 l=1.5
X97 Vg27.t22 Vd24.t10 Vg28.t9 GND.t27 sky130_fd_pr__nfet_g5v0d10v5 ad=1.45 pd=10.29 as=2.9 ps=20.58 w=10 l=0.5
X98 Vout Vg27.t27 VDD.t15 VDD.t14 sky130_fd_pr__pfet_g5v0d10v5 ad=2.175 pd=15.29 as=2.175 ps=15.29 w=15 l=0.5
X99 Vs29 Vp.t1 Vd29 GND.t2 sky130_fd_pr__nfet_g5v0d10v5 ad=1.61095 pd=11.4 as=1.61095 ps=11.4 w=11.11 l=1.5
X100 Vg28.t16 Vg22.t20 Vg27.t8 VDD.t103 sky130_fd_pr__pfet_g5v0d10v5 ad=1.45 pd=10.29 as=1.45 ps=10.29 w=10 l=0.5
X101 VDD.t53 Vg5.t10 a_26297_13170# VDD.t2 sky130_fd_pr__pfet_g5v0d10v5 ad=1.45 pd=10.29 as=2.9 ps=20.58 w=10 l=5
X102 Vd10 Vn.t16 Vd8.t15 Vd8.t13 sky130_fd_pr__pfet_g5v0d10v5 ad=3.2219 pd=22.51 as=3.2219 ps=22.51 w=22.22 l=1.5
X103 Vg28.t27 Vout.t0 sky130_fd_pr__cap_mim_m3_1 l=20 w=30
X104 VDD.t38 Vg27.t40 Vout VDD.t37 sky130_fd_pr__pfet_g5v0d10v5 ad=2.175 pd=15.29 as=2.175 ps=15.29 w=15 l=0.5
X105 Vg27.t15 Vg22.t13 Vg28.t4 VDD.t45 sky130_fd_pr__pfet_g5v0d10v5 ad=1.45 pd=10.29 as=1.45 ps=10.29 w=10 l=0.5
X106 Vg28.t0 Vd24.t13 Vg27.t19 GND.t3 sky130_fd_pr__nfet_g5v0d10v5 ad=1.45 pd=10.29 as=1.45 ps=10.29 w=10 l=0.5
X107 VDD.t92 Vg27.t26 Vout VDD.t91 sky130_fd_pr__pfet_g5v0d10v5 ad=2.175 pd=15.29 as=4.35 ps=30.58 w=15 l=0.5
X108 Vg27.t5 Vg22.t23 Vg28.t18 VDD.t105 sky130_fd_pr__pfet_g5v0d10v5 ad=1.45 pd=10.29 as=1.45 ps=10.29 w=10 l=0.5
X109 Vd29 Vg11.t17 Vg27.t1 VDD.t4 sky130_fd_pr__pfet_g5v0d10v5 ad=1.45 pd=10.29 as=2.9 ps=20.58 w=10 l=1
X110 VDD.t29 Vg5 Vd24 VDD.t28 sky130_fd_pr__pfet_g5v0d10v5 ad=1.16 pd=8.58 as=1.16 ps=8.58 w=4 l=5
X111 VDD.t60 Vg27.t30 Vout VDD.t59 sky130_fd_pr__pfet_g5v0d10v5 ad=2.175 pd=15.29 as=2.175 ps=15.29 w=15 l=0.5
X112 Vg11.t16 Vg1 Vd10 GND.t38 sky130_fd_pr__nfet_g5v0d10v5 ad=2.0735 pd=14.59 as=4.147 ps=29.18 w=14.3 l=2
X113 Vd8.t1 Vp.t17 Vd9 Vd8.t0 sky130_fd_pr__pfet_g5v0d10v5 ad=6.4438 pd=45.02 as=3.2219 ps=22.51 w=22.22 l=1.5
X114 Vd10 Vg1 Vg11.t15 GND.t38 sky130_fd_pr__nfet_g5v0d10v5 ad=2.0735 pd=14.59 as=2.0735 ps=14.59 w=14.3 l=2
X115 Vg11.t14 Vg1 Vd10 GND.t38 sky130_fd_pr__nfet_g5v0d10v5 ad=2.0735 pd=14.59 as=2.0735 ps=14.59 w=14.3 l=2
X116 Vd10 Vg1 Vg11.t13 GND.t38 sky130_fd_pr__nfet_g5v0d10v5 ad=2.0735 pd=14.59 as=2.0735 ps=14.59 w=14.3 l=2
X117 Vout Vg27.t33 VDD.t12 VDD.t11 sky130_fd_pr__pfet_g5v0d10v5 ad=2.175 pd=15.29 as=2.175 ps=15.29 w=15 l=0.5
X118 Vg22.t3 Vg22.t2 m21_22_0.G VDD.t78 sky130_fd_pr__pfet_g5v0d10v5 ad=2.175 pd=15.29 as=2.175 ps=15.29 w=15 l=0.5
X119 Vg27.t9 Vg22.t19 Vg28.t12 VDD.t95 sky130_fd_pr__pfet_g5v0d10v5 ad=1.45 pd=10.29 as=1.45 ps=10.29 w=10 l=0.5
X120 Vd29 Vg11.t25 VDD.t58 VDD.t4 sky130_fd_pr__pfet_g5v0d10v5 ad=1.45 pd=10.29 as=1.45 ps=10.29 w=10 l=2.5
X121 Vd8.t20 Vn.t11 Vd10 Vd8.t13 sky130_fd_pr__pfet_g5v0d10v5 ad=3.2219 pd=22.51 as=3.2219 ps=22.51 w=22.22 l=1.5
X122 VDD.t69 Vg11.t24 Vd29 VDD.t4 sky130_fd_pr__pfet_g5v0d10v5 ad=1.45 pd=10.29 as=1.45 ps=10.29 w=10 l=2.5
X123 Vs29 Vn.t7 Vd30 GND.t14 sky130_fd_pr__nfet_g5v0d10v5 ad=1.61095 pd=11.4 as=1.61095 ps=11.4 w=11.11 l=1.5
X124 m21_22_0.G Vg22.t4 Vg22.t5 VDD.t84 sky130_fd_pr__pfet_g5v0d10v5 ad=2.175 pd=15.29 as=2.175 ps=15.29 w=15 l=0.5
X125 a_40258_n12.t0 Vd24.t6 Vd24.t7 GND.t8 sky130_fd_pr__nfet_g5v0d10v5 ad=0.725 pd=5.29 as=0.725 ps=5.29 w=5 l=0.5
X126 Vout Vg27.t29 VDD.t1 VDD.t0 sky130_fd_pr__pfet_g5v0d10v5 ad=2.175 pd=15.29 as=2.175 ps=15.29 w=15 l=0.5
X127 Vg11.t12 Vg1 Vd10 GND.t38 sky130_fd_pr__nfet_g5v0d10v5 ad=2.0735 pd=14.59 as=2.0735 ps=14.59 w=14.3 l=2
X128 Vd30 Vg11.t4 Vg11.t5 VDD.t7 sky130_fd_pr__pfet_g5v0d10v5 ad=1.45 pd=10.29 as=1.45 ps=10.29 w=10 l=1
X129 Vd8.t3 Vp.t15 Vd9 Vd8.t0 sky130_fd_pr__pfet_g5v0d10v5 ad=3.2219 pd=22.51 as=3.2219 ps=22.51 w=22.22 l=1.5
X130 Vg28.t10 Vg22.t18 Vg27.t10 VDD.t87 sky130_fd_pr__pfet_g5v0d10v5 ad=1.45 pd=10.29 as=1.45 ps=10.29 w=10 l=0.5
X131 VDD.t23 m21_22_0.G.t0 m21_22_0.G.t1 VDD.t22 sky130_fd_pr__pfet_g5v0d10v5 ad=4.35 pd=30.58 as=2.175 ps=15.29 w=15 l=0.5
X132 Vg27.t20 Vd24.t12 Vg28.t2 GND.t6 sky130_fd_pr__nfet_g5v0d10v5 ad=1.45 pd=10.29 as=1.45 ps=10.29 w=10 l=0.5
X133 Vd30 Vn.t4 Vs29 GND.t14 sky130_fd_pr__nfet_g5v0d10v5 ad=1.61095 pd=11.4 as=1.61095 ps=11.4 w=11.11 l=1.5
X134 Vg28.t17 Vg22.t22 Vg27.t6 VDD.t104 sky130_fd_pr__pfet_g5v0d10v5 ad=1.45 pd=10.29 as=1.45 ps=10.29 w=10 l=0.5
X135 Vg28.t26 Vg1 Vd9 GND.t39 sky130_fd_pr__nfet_g5v0d10v5 ad=2.0735 pd=14.59 as=4.147 ps=29.18 w=14.3 l=2
X136 Vg27.t13 Vg22.t15 Vg28.t6 VDD.t48 sky130_fd_pr__pfet_g5v0d10v5 ad=1.45 pd=10.29 as=1.45 ps=10.29 w=10 l=0.5
X137 Vd9 Vg1 Vg28.t25 GND.t39 sky130_fd_pr__nfet_g5v0d10v5 ad=2.0735 pd=14.59 as=2.0735 ps=14.59 w=14.3 l=2
X138 Vg28.t24 Vg1 Vd9 GND.t39 sky130_fd_pr__nfet_g5v0d10v5 ad=2.0735 pd=14.59 as=2.0735 ps=14.59 w=14.3 l=2
X139 Vd9 Vg1 Vg28.t23 GND.t39 sky130_fd_pr__nfet_g5v0d10v5 ad=2.0735 pd=14.59 as=2.0735 ps=14.59 w=14.3 l=2
X140 Vout Vg27.t35 VDD.t77 VDD.t76 sky130_fd_pr__pfet_g5v0d10v5 ad=2.175 pd=15.29 as=2.175 ps=15.29 w=15 l=0.5
X141 VDD.t32 Vg27.t28 Vout VDD.t31 sky130_fd_pr__pfet_g5v0d10v5 ad=2.175 pd=15.29 as=2.175 ps=15.29 w=15 l=0.5
X142 Vs29 Vp.t7 Vd29 GND.t2 sky130_fd_pr__nfet_g5v0d10v5 ad=1.61095 pd=11.4 as=1.61095 ps=11.4 w=11.11 l=1.5
X143 Vg5.t1 Vg5.t2 a_23419_13228# VDD.t10 sky130_fd_pr__pfet_g5v0d10v5 ad=0.957 pd=6.89 as=0.957 ps=6.89 w=6.6 l=2
X144 Vg28.t1 Vg22.t14 Vg27.t14 VDD.t21 sky130_fd_pr__pfet_g5v0d10v5 ad=1.45 pd=10.29 as=1.45 ps=10.29 w=10 l=0.5
X145 a_23419_13228# Vg5.t0 Vg5.t1 VDD.t10 sky130_fd_pr__pfet_g5v0d10v5 ad=1.914 pd=13.78 as=0.957 ps=6.89 w=6.6 l=2
X146 VDD.t97 m21_22_0.G.t8 m21_22_0.G VDD.t96 sky130_fd_pr__pfet_g5v0d10v5 ad=2.175 pd=15.29 as=4.35 ps=30.58 w=15 l=0.5
X147 a_40258_n12.t1 Vd24.t2 Vd24.t3 GND.t9 sky130_fd_pr__nfet_g5v0d10v5 ad=0.725 pd=5.29 as=0.725 ps=5.29 w=5 l=0.5
X148 m21_22_0.G.t3 m21_22_0.G.t2 VDD.t6 VDD.t5 sky130_fd_pr__pfet_g5v0d10v5 ad=2.175 pd=15.29 as=2.175 ps=15.29 w=15 l=0.5
X149 Vg28.t27 Vout.t0 sky130_fd_pr__cap_mim_m3_1 l=20 w=30
X150 Vg28.t22 Vg1 Vd9 GND.t39 sky130_fd_pr__nfet_g5v0d10v5 ad=2.0735 pd=14.59 as=2.0735 ps=14.59 w=14.3 l=2
X151 Vg28.t3 Vd24.t11 Vg27.t21 GND.t7 sky130_fd_pr__nfet_g5v0d10v5 ad=1.45 pd=10.29 as=1.45 ps=10.29 w=10 l=0.5
X152 Vg27.t7 Vg22.t21 Vg28.t19 VDD.t106 sky130_fd_pr__pfet_g5v0d10v5 ad=1.45 pd=10.29 as=1.45 ps=10.29 w=10 l=0.5
X153 Vd8.t5 Vp.t13 Vd9 Vd8.t0 sky130_fd_pr__pfet_g5v0d10v5 ad=3.2219 pd=22.51 as=3.2219 ps=22.51 w=22.22 l=1.5
X154 Vd30 Vn.t2 Vs29 GND.t14 sky130_fd_pr__nfet_g5v0d10v5 ad=1.61095 pd=11.4 as=1.61095 ps=11.4 w=11.11 l=1.5
X155 Vd29 Vp.t4 Vs29 GND.t2 sky130_fd_pr__nfet_g5v0d10v5 ad=1.61095 pd=11.4 as=1.61095 ps=11.4 w=11.11 l=1.5
X156 Vg27.t25 Vout.t0 sky130_fd_pr__cap_mim_m3_1 l=20 w=30
X157 Vg1 Vg1 m01_02.sky130_fd_pr__nfet_g5v0d10v5_Y3KDPX_0.D GND.t35 sky130_fd_pr__nfet_g5v0d10v5 ad=0.48285 pd=3.62 as=0.9657 ps=7.24 w=3.33 l=2
X158 Vg27.t11 Vg22.t17 Vg28.t8 VDD.t81 sky130_fd_pr__pfet_g5v0d10v5 ad=1.45 pd=10.29 as=1.45 ps=10.29 w=10 l=0.5
X159 Vd24.t5 Vd24.t4 a_40258_n12.t13 GND.t31 sky130_fd_pr__nfet_g5v0d10v5 ad=0.725 pd=5.29 as=0.725 ps=5.29 w=5 l=0.5
X160 Vd30 Vg11.t28 VDD.t72 VDD.t7 sky130_fd_pr__pfet_g5v0d10v5 ad=1.45 pd=10.29 as=1.45 ps=10.29 w=10 l=2.5
X161 VDD.t57 m21_22_0.G.t4 m21_22_0.G.t5 VDD.t56 sky130_fd_pr__pfet_g5v0d10v5 ad=2.175 pd=15.29 as=2.175 ps=15.29 w=15 l=0.5
X162 GND.t11 Vg28.t37 Vout GND.t22 sky130_fd_pr__nfet_g5v0d10v5 ad=1.45 pd=10.29 as=1.45 ps=10.29 w=10 l=0.5
X163 VDD.t50 VgR2 VgR2 VDD.t49 sky130_fd_pr__pfet_g5v0d10v5 ad=1.16 pd=8.58 as=1.16 ps=8.58 w=4 l=5
X164 Vd29 Vp.t2 Vs29 GND.t2 sky130_fd_pr__nfet_g5v0d10v5 ad=1.61095 pd=11.4 as=1.61095 ps=11.4 w=11.11 l=1.5
X165 Vg27.t25 Vout.t2 sky130_fd_pr__cap_mim_m3_1 l=20 w=30
X166 Vg28.t15 Vg22.t16 Vg27.t12 VDD.t102 sky130_fd_pr__pfet_g5v0d10v5 ad=1.45 pd=10.29 as=1.45 ps=10.29 w=10 l=0.5
X167 a_27266_764# Vg1 GND.t46 GND.t45 sky130_fd_pr__nfet_g5v0d10v5 ad=2.9 pd=20.58 as=2.9 ps=20.58 w=10 l=5
X168 VDD.t3 Vg5.t12 a_26297_13170# VDD.t2 sky130_fd_pr__pfet_g5v0d10v5 ad=2.9 pd=20.58 as=1.45 ps=10.29 w=10 l=5
X169 m21_22_0.G.t7 m21_22_0.G.t6 VDD.t99 VDD.t98 sky130_fd_pr__pfet_g5v0d10v5 ad=2.175 pd=15.29 as=2.175 ps=15.29 w=15 l=0.5
X170 Vd10 Vg1 Vg11.t11 GND.t38 sky130_fd_pr__nfet_g5v0d10v5 ad=2.0735 pd=14.59 as=2.0735 ps=14.59 w=14.3 l=2
X171 Vd30 Vg11.t0 Vg11.t1 VDD.t7 sky130_fd_pr__pfet_g5v0d10v5 ad=2.9 pd=20.58 as=1.45 ps=10.29 w=10 l=1
X172 Vd8.t7 Vp.t11 Vd9 Vd8.t0 sky130_fd_pr__pfet_g5v0d10v5 ad=3.2219 pd=22.51 as=3.2219 ps=22.51 w=22.22 l=1.5
X173 Vd24.t1 Vd24.t0 a_40258_n12.t14 GND.t34 sky130_fd_pr__nfet_g5v0d10v5 ad=1.45 pd=10.58 as=0.725 ps=5.29 w=5 l=0.5
X174 Vg11.t10 Vg1 Vd10 GND.t38 sky130_fd_pr__nfet_g5v0d10v5 ad=4.147 pd=29.18 as=2.0735 ps=14.59 w=14.3 l=2
X175 VDD.t75 Vg11.t31 Vd30 VDD.t7 sky130_fd_pr__pfet_g5v0d10v5 ad=2.9 pd=20.58 as=1.45 ps=10.29 w=10 l=2.5
X176 m01_02.sky130_fd_pr__nfet_g5v0d10v5_Y3KDPX_0.D Vg1 GND.t42 GND.t35 sky130_fd_pr__nfet_g5v0d10v5 ad=1.45 pd=10.58 as=1.45 ps=10.58 w=5 l=5
X177 Vg28.t5 Vg22.t12 Vg27.t16 VDD.t47 sky130_fd_pr__pfet_g5v0d10v5 ad=1.45 pd=10.29 as=1.45 ps=10.29 w=10 l=0.5
X178 Vs29 Vn.t5 Vd30 GND.t14 sky130_fd_pr__nfet_g5v0d10v5 ad=1.61095 pd=11.4 as=1.61095 ps=11.4 w=11.11 l=1.5
X179 Vg27.t25 Vout.t0 sky130_fd_pr__cap_mim_m3_1 l=20 w=30
X180 Vout Vg28.t42 GND.t11 GND.t32 sky130_fd_pr__nfet_g5v0d10v5 ad=2.9 pd=20.58 as=1.45 ps=10.29 w=10 l=0.5
X181 Vd10 Vn.t14 Vd8.t17 Vd8.t13 sky130_fd_pr__pfet_g5v0d10v5 ad=3.2219 pd=22.51 as=3.2219 ps=22.51 w=22.22 l=1.5
X182 Vs29 Vg1 a_27266_764# GND.t37 sky130_fd_pr__nfet_g5v0d10v5 ad=0.9657 pd=6.95 as=1.9314 ps=13.9 w=6.66 l=2
X183 a_26297_13170# Vg5.t11 VDD.t55 VDD.t2 sky130_fd_pr__pfet_g5v0d10v5 ad=1.45 pd=10.29 as=1.45 ps=10.29 w=10 l=5
X184 Vg11.t3 Vg11.t2 Vd30 VDD.t7 sky130_fd_pr__pfet_g5v0d10v5 ad=1.45 pd=10.29 as=1.45 ps=10.29 w=10 l=1
X185 Vd9 Vp.t16 Vd8.t2 Vd8.t0 sky130_fd_pr__pfet_g5v0d10v5 ad=3.2219 pd=22.51 as=3.2219 ps=22.51 w=22.22 l=1.5
X186 Vd8.t22 Vn.t9 Vd10 Vd8.t13 sky130_fd_pr__pfet_g5v0d10v5 ad=3.2219 pd=22.51 as=6.4438 ps=45.02 w=22.22 l=1.5
X187 a_27266_764# Vg1 Vs29 GND.t37 sky130_fd_pr__nfet_g5v0d10v5 ad=0.9657 pd=6.95 as=0.9657 ps=6.95 w=6.66 l=2
X188 Vg27.t17 Vg22.t11 Vg28.t7 VDD.t67 sky130_fd_pr__pfet_g5v0d10v5 ad=1.45 pd=10.29 as=2.9 ps=20.58 w=10 l=0.5
R0 Vout Vout.t0 1.93822
R1 Vout.t0 Vout.t6 1.79692
R2 Vout.t0 Vout.t2 1.51123
R3 Vn.n4 Vn.t17 156.665
R4 Vn.n5 Vn.t16 152.913
R5 Vn.n8 Vn.t15 152.913
R6 Vn.n10 Vn.t14 152.913
R7 Vn.n13 Vn.t13 152.913
R8 Vn.n15 Vn.t12 152.913
R9 Vn.n18 Vn.t11 152.913
R10 Vn.n20 Vn.t10 152.913
R11 Vn.n22 Vn.t9 152.913
R12 Vn.n22 Vn.n21 119.165
R13 Vn.n6 Vn.n4 113.156
R14 Vn.n4 Vn.n3 112.374
R15 Vn.n21 Vn.n20 101.017
R16 Vn.n19 Vn.n18 101.017
R17 Vn.n15 Vn.n1 101.017
R18 Vn.n13 Vn.n12 101.017
R19 Vn.n11 Vn.n10 101.017
R20 Vn.n9 Vn.n8 101.017
R21 Vn.n5 Vn.n3 101.017
R22 Vn.n23 Vn.n22 100.844
R23 Vn.n20 Vn.n0 100.844
R24 Vn.n18 Vn.n17 100.844
R25 Vn.n16 Vn.n15 100.844
R26 Vn.n14 Vn.n13 100.844
R27 Vn.n10 Vn.n2 100.844
R28 Vn.n8 Vn.n7 100.844
R29 Vn.n6 Vn.n5 100.844
R30 Vn.n28 Vn.t0 88.3013
R31 Vn.n29 Vn.t1 88.3013
R32 Vn.n32 Vn.t2 88.3013
R33 Vn.n34 Vn.t3 88.3013
R34 Vn.n37 Vn.t4 88.3013
R35 Vn.n39 Vn.t5 88.3013
R36 Vn.t8 Vn.n43 68.9715
R37 Vn.n28 Vn.n27 68.6475
R38 Vn.n30 Vn.n28 68.5461
R39 Vn.n44 Vn.t8 50.0177
R40 Vn.t7 Vn.n24 50.0177
R41 Vn.t6 Vn.n41 50.0177
R42 Vn.n40 Vn.n39 50.0177
R43 Vn.n38 Vn.n37 50.0177
R44 Vn.n34 Vn.n26 50.0177
R45 Vn.n32 Vn.n31 50.0177
R46 Vn.n30 Vn.n29 50.0177
R47 Vn.n43 Vn.t7 49.9111
R48 Vn.n42 Vn.t6 49.9111
R49 Vn.n39 Vn.n25 49.9111
R50 Vn.n37 Vn.n36 49.9111
R51 Vn.n35 Vn.n34 49.9111
R52 Vn.n33 Vn.n32 49.9111
R53 Vn.n29 Vn.n27 49.9111
R54 Vn.n17 Vn.n0 23.1086
R55 Vn.n7 Vn.n2 23.1086
R56 Vn.n17 Vn.n16 22.7925
R57 Vn.n7 Vn.n6 22.1604
R58 Vn.n11 Vn.n9 21.887
R59 Vn.n21 Vn.n19 21.887
R60 Vn.n16 Vn.n14 21.8444
R61 Vn.n19 Vn.n1 21.5993
R62 Vn.n9 Vn.n3 21.0241
R63 Vn.n35 Vn.n33 21.0053
R64 Vn.n31 Vn.n26 20.7412
R65 Vn.n12 Vn.n1 20.7364
R66 Vn.n33 Vn.n27 20.6812
R67 Vn.n31 Vn.n30 20.4252
R68 Vn.n43 Vn.n42 20.3572
R69 Vn.n42 Vn.n25 20.3572
R70 Vn.n36 Vn.n25 20.3572
R71 Vn.n41 Vn.n24 20.1091
R72 Vn.n41 Vn.n40 20.1091
R73 Vn.n40 Vn.n38 20.1091
R74 Vn.n14 Vn.n2 19.632
R75 Vn.n23 Vn.n0 18.9999
R76 Vn.n44 Vn.n24 18.8449
R77 Vn.n36 Vn.n35 18.7369
R78 Vn.n12 Vn.n11 18.7229
R79 Vn.n38 Vn.n26 18.5289
R80 Vn Vn.n23 10.0505
R81 Vn Vn.n44 3.45555
R82 Vp.n25 Vp.t17 156.665
R83 Vp.n26 Vp.t16 152.913
R84 Vp.n29 Vp.t15 152.913
R85 Vp.n31 Vp.t14 152.913
R86 Vp.n34 Vp.t13 152.913
R87 Vp.n36 Vp.t12 152.913
R88 Vp.n39 Vp.t11 152.913
R89 Vp.n41 Vp.t10 152.913
R90 Vp.n43 Vp.t9 152.913
R91 Vp.n43 Vp.n42 119.222
R92 Vp.n27 Vp.n25 113.103
R93 Vp.n25 Vp.n24 112.425
R94 Vp.n42 Vp.n41 101.075
R95 Vp.n40 Vp.n39 101.075
R96 Vp.n36 Vp.n22 101.075
R97 Vp.n34 Vp.n33 101.075
R98 Vp.n32 Vp.n31 101.075
R99 Vp.n30 Vp.n29 101.075
R100 Vp.n26 Vp.n24 101.075
R101 Vp.n44 Vp.n43 100.787
R102 Vp.n41 Vp.n21 100.787
R103 Vp.n39 Vp.n38 100.787
R104 Vp.n37 Vp.n36 100.787
R105 Vp.n35 Vp.n34 100.787
R106 Vp.n31 Vp.n23 100.787
R107 Vp.n29 Vp.n28 100.787
R108 Vp.n27 Vp.n26 100.787
R109 Vp.n4 Vp.t0 88.3013
R110 Vp.n5 Vp.t1 88.3013
R111 Vp.n8 Vp.t2 88.3013
R112 Vp.n10 Vp.t3 88.3013
R113 Vp.n13 Vp.t4 88.3013
R114 Vp.n15 Vp.t5 88.3013
R115 Vp.t8 Vp.n19 69.0249
R116 Vp.n4 Vp.n3 68.7008
R117 Vp.n6 Vp.n4 68.4928
R118 Vp.n20 Vp.t8 49.9644
R119 Vp.n19 Vp.t7 49.9644
R120 Vp.t7 Vp.n0 49.9644
R121 Vp.n18 Vp.t6 49.9644
R122 Vp.t6 Vp.n17 49.9644
R123 Vp.n15 Vp.n1 49.9644
R124 Vp.n16 Vp.n15 49.9644
R125 Vp.n13 Vp.n12 49.9644
R126 Vp.n14 Vp.n13 49.9644
R127 Vp.n11 Vp.n10 49.9644
R128 Vp.n10 Vp.n2 49.9644
R129 Vp.n9 Vp.n8 49.9644
R130 Vp.n8 Vp.n7 49.9644
R131 Vp.n5 Vp.n3 49.9644
R132 Vp.n6 Vp.n5 49.9644
R133 Vp.n38 Vp.n21 23.1086
R134 Vp.n28 Vp.n23 23.1086
R135 Vp.n38 Vp.n37 22.7925
R136 Vp.n28 Vp.n27 22.1604
R137 Vp.n32 Vp.n30 21.887
R138 Vp.n42 Vp.n40 21.887
R139 Vp.n37 Vp.n35 21.8444
R140 Vp.n40 Vp.n22 21.5993
R141 Vp.n30 Vp.n24 21.0241
R142 Vp.n11 Vp.n9 21.0053
R143 Vp.n7 Vp.n2 20.7412
R144 Vp.n33 Vp.n22 20.7364
R145 Vp.n9 Vp.n3 20.6812
R146 Vp.n7 Vp.n6 20.4252
R147 Vp.n19 Vp.n18 20.3572
R148 Vp.n18 Vp.n1 20.3572
R149 Vp.n12 Vp.n1 20.3572
R150 Vp.n17 Vp.n16 20.1091
R151 Vp.n16 Vp.n14 20.1091
R152 Vp.n17 Vp.n0 20.1091
R153 Vp.n35 Vp.n23 19.632
R154 Vp.n44 Vp.n21 18.9999
R155 Vp.n20 Vp.n0 18.8449
R156 Vp.n12 Vp.n11 18.7369
R157 Vp.n33 Vp.n32 18.7229
R158 Vp.n14 Vp.n2 18.5289
R159 Vp Vp.n44 8.31972
R160 Vp Vp.n20 4.27047
R161 VDD.n116 VDD.n100 7433.59
R162 VDD.n115 VDD.n100 7433.59
R163 VDD.n116 VDD.n22 7433.59
R164 VDD.n115 VDD.n22 7433.59
R165 VDD.n175 VDD.n55 5688.21
R166 VDD.n164 VDD.n55 5688.21
R167 VDD.n146 VDD.n2 5310.83
R168 VDD.n154 VDD.n70 5310.83
R169 VDD.n132 VDD.n130 4898.07
R170 VDD.n131 VDD.n130 4898.07
R171 VDD.n131 VDD.n128 4898.07
R172 VDD.n132 VDD.n128 4898.07
R173 VDD.n178 VDD.n18 19.7066
R174 VDD.n172 VDD.n57 4548.21
R175 VDD.n166 VDD.n57 4548.21
R176 VDD.n95 VDD.n80 4328.07
R177 VDD.n96 VDD.n80 4328.07
R178 VDD.n91 VDD.n85 4328.07
R179 VDD.n85 VDD.n0 4328.07
R180 VDD.n155 VDD.n64 3836.69
R181 VDD.n136 VDD.n11 3836.69
R182 VDD.n94 VDD.n93 3345.31
R183 VDD.n93 VDD.n82 3345.31
R184 VDD.n175 VDD.n56 3325.66
R185 VDD.n164 VDD.n157 3325.66
R186 VDD.n179 VDD.n50 3325.66
R187 VDD.n16 VDD.n52 3325.66
R188 VDD.n58 VDD.n51 3250.97
R189 VDD.n76 VDD.n2 2948.28
R190 VDD.n70 VDD.n69 2948.28
R191 VDD.n78 VDD.n77 2948.28
R192 VDD.n77 VDD.n68 2948.28
R193 VDD.n42 VDD.n39 2429.38
R194 VDD.n45 VDD.n38 2429.38
R195 VDD.n34 VDD.n29 2429.38
R196 VDD.n32 VDD.n31 2429.38
R197 VDD.n124 VDD.n119 2429.38
R198 VDD.n121 VDD.n120 2429.38
R199 VDD.n160 VDD.n56 2395.97
R200 VDD.n154 VDD.n68 2362.55
R201 VDD.n146 VDD.n68 2362.55
R202 VDD.n69 VDD.n67 2362.55
R203 VDD.n78 VDD.n67 2362.55
R204 VDD.n145 VDD.n78 2362.55
R205 VDD.n145 VDD.n76 2362.55
R206 VDD.n155 VDD.n63 2362.55
R207 VDD.n11 VDD.n63 2362.55
R208 VDD.n160 VDD.n157 2329.14
R209 VDD.n166 VDD.n157 2219.07
R210 VDD.n172 VDD.n56 2152.24
R211 VDD.n183 VDD.n50 1886.9
R212 VDD.n58 VDD.n52 1855.45
R213 VDD.n69 VDD.n64 1474.14
R214 VDD.n139 VDD.n63 1474.14
R215 VDD.n139 VDD.n78 1474.14
R216 VDD.n136 VDD.n76 1474.14
R217 VDD.n182 VDD.n52 1395.52
R218 VDD.n182 VDD.n50 1364.07
R219 VDD.n181 VDD.n180 1172.74
R220 VDD.n95 VDD.n94 982.76
R221 VDD.n96 VDD.n82 982.76
R222 VDD.n91 VDD.n82 982.76
R223 VDD.n94 VDD.n0 982.76
R224 VDD.n178 VDD.n14 930.322
R225 VDD.n173 VDD.t30 681.386
R226 VDD.n84 VDD.n83 634.354
R227 VDD.n84 VDD.n81 634.354
R228 VDD.n159 VDD.n158 629.347
R229 VDD.n143 VDD.n71 569.225
R230 VDD.n148 VDD.n71 569.225
R231 VDD.n48 VDD.n24 459.733
R232 VDD.n35 VDD.n28 455.385
R233 VDD.n143 VDD.n142 452.519
R234 VDD.n144 VDD.n143 452.519
R235 VDD.n58 VDD.t24 451.259
R236 VDD.n142 VDD.n141 446.118
R237 VDD.n144 VDD.n138 446.118
R238 VDD.n48 VDD.n25 441.615
R239 VDD.n159 VDD.n156 439.719
R240 VDD.n183 VDD.t10 398.587
R241 VDD.n20 VDD.n60 384
R242 VDD.n45 VDD.n44 333.202
R243 VDD.n43 VDD.n42 333.202
R244 VDD.n31 VDD.n30 333.202
R245 VDD.n34 VDD.n33 333.202
R246 VDD.n122 VDD.n119 333.202
R247 VDD.n123 VDD.n120 333.202
R248 VDD.n49 VDD.n48 326.046
R249 VDD.n153 VDD.n149 287.488
R250 VDD.n140 VDD.n12 286.872
R251 VDD.n143 VDD.n140 286.872
R252 VDD.n181 VDD.n15 260.894
R253 VDD.n47 VDD.n46 258.43
R254 VDD.n134 VDD.n133 253.971
R255 VDD.n46 VDD.n37 243.201
R256 VDD.t7 VDD.n66 237.6
R257 VDD.t7 VDD.n65 237.6
R258 VDD.t4 VDD.n65 237.6
R259 VDD.t4 VDD.n75 237.6
R260 VDD.n158 VDD.n15 217.732
R261 VDD.n174 VDD.t2 216.516
R262 VDD.n165 VDD.n161 213.453
R263 VDD.n16 VDD.n18 189.264
R264 VDD.n179 VDD.t24 189.248
R265 VDD.n141 VDD.n59 161.992
R266 VDD.n180 VDD.n14 155.201
R267 VDD.n166 VDD.n165 151.013
R268 VDD.n129 VDD.n127 128.802
R269 VDD.n114 VDD.n113 118.13
R270 VDD.n173 VDD.n172 116.269
R271 VDD.n141 VDD.n61 110.791
R272 VDD.n20 VDD.n61 108.374
R273 VDD.t67 VDD.n130 83.6135
R274 VDD.t101 VDD.n128 83.6135
R275 VDD.n114 VDD.n4 76.5079
R276 VDD.n113 VDD.n99 74.2606
R277 VDD.n27 VDD.n25 62.1286
R278 VDD.n24 VDD.t50 62.0164
R279 VDD.n21 VDD.t29 60.7747
R280 VDD.t20 VDD.n80 60.1568
R281 VDD.n85 VDD.t22 60.1568
R282 VDD.t91 VDD.n100 60.1568
R283 VDD.t93 VDD.n22 60.1568
R284 VDD.n26 VDD.t52 60.1061
R285 VDD.n169 VDD.n168 57.9178
R286 VDD.t47 VDD.t67 57.8648
R287 VDD.t45 VDD.t47 57.8648
R288 VDD.t21 VDD.t45 57.8648
R289 VDD.t48 VDD.t21 57.8648
R290 VDD.t102 VDD.t48 57.8648
R291 VDD.t81 VDD.t102 57.8648
R292 VDD.t87 VDD.t81 57.8648
R293 VDD.t87 VDD.t95 57.8648
R294 VDD.t95 VDD.t103 57.8648
R295 VDD.t103 VDD.t106 57.8648
R296 VDD.t106 VDD.t104 57.8648
R297 VDD.t104 VDD.t105 57.8648
R298 VDD.t105 VDD.t100 57.8648
R299 VDD.t100 VDD.t101 57.8648
R300 VDD.n92 VDD.t13 56.3027
R301 VDD.n92 VDD.t96 56.3027
R302 VDD.n149 VDD.n59 55.4672
R303 VDD.n178 VDD.n177 49.767
R304 VDD.n48 VDD.n47 48.6695
R305 VDD.n41 VDD.n40 47.6179
R306 VDD.n178 VDD.t107 47.3252
R307 VDD.n171 VDD.n169 46.1796
R308 VDD.n158 VDD.n5 43.8308
R309 VDD.t46 VDD.t20 41.7645
R310 VDD.t84 VDD.t46 41.7645
R311 VDD.t84 VDD.t78 41.7645
R312 VDD.t13 VDD.t78 41.7645
R313 VDD.t96 VDD.t98 41.7645
R314 VDD.t98 VDD.t56 41.7645
R315 VDD.t56 VDD.t5 41.7645
R316 VDD.t22 VDD.t5 41.7645
R317 VDD.t14 VDD.t91 41.7645
R318 VDD.t31 VDD.t14 41.7645
R319 VDD.t0 VDD.t31 41.7645
R320 VDD.t59 VDD.t0 41.7645
R321 VDD.t26 VDD.t59 41.7645
R322 VDD.t8 VDD.t26 41.7645
R323 VDD.t11 VDD.t8 41.7645
R324 VDD.t61 VDD.t11 41.7645
R325 VDD.t76 VDD.t61 41.7645
R326 VDD.t88 VDD.t76 41.7645
R327 VDD.t82 VDD.t88 41.7645
R328 VDD.t63 VDD.t82 41.7645
R329 VDD.t63 VDD.t16 41.7645
R330 VDD.t16 VDD.t37 41.7645
R331 VDD.t37 VDD.t33 41.7645
R332 VDD.t33 VDD.t41 41.7645
R333 VDD.t41 VDD.t65 41.7645
R334 VDD.t65 VDD.t18 41.7645
R335 VDD.t18 VDD.t79 41.7645
R336 VDD.t79 VDD.t39 41.7645
R337 VDD.t39 VDD.t35 41.7645
R338 VDD.t35 VDD.t43 41.7645
R339 VDD.t43 VDD.t85 41.7645
R340 VDD.t85 VDD.t93 41.7645
R341 VDD.n129 VDD.n60 39.5634
R342 VDD.n162 VDD.n54 37.8419
R343 VDD.n41 VDD.n26 37.6672
R344 VDD.n54 VDD.n53 30.4176
R345 VDD.n168 VDD.n59 29.1998
R346 VDD.n152 VDD.n150 27.3366
R347 VDD.n74 VDD.n72 27.3366
R348 VDD.n152 VDD.n151 23.6336
R349 VDD.n74 VDD.n73 23.6336
R350 VDD.n133 VDD.n127 23.4932
R351 VDD.n153 VDD.t75 22.9424
R352 VDD.n147 VDD.t70 22.9424
R353 VDD.n54 VDD.t3 22.9424
R354 VDD.n170 VDD.n49 22.6281
R355 VDD.n171 VDD.n170 22.6281
R356 VDD.n36 VDD.n35 22.5903
R357 VDD.n147 VDD.n1 22.4056
R358 VDD.n127 VDD.n126 21.6831
R359 VDD.n40 VDD.n37 20.0672
R360 VDD.n36 VDD.n27 20.0219
R361 VDD.n176 VDD.n54 19.3721
R362 VDD.n88 VDD.n86 18.7777
R363 VDD.n6 VDD.n112 18.508
R364 VDD.n163 VDD.n156 18.4966
R365 VDD.n88 VDD.n87 17.9682
R366 VDD.n9 VDD.n103 17.8806
R367 VDD.n6 VDD.n111 17.8797
R368 VDD.n7 VDD.n108 17.8787
R369 VDD.n9 VDD.n104 17.8785
R370 VDD.n10 VDD.n102 17.8783
R371 VDD.n8 VDD.n105 17.8743
R372 VDD.n7 VDD.n106 17.874
R373 VDD.n10 VDD.n101 17.8738
R374 VDD.n7 VDD.n107 17.8736
R375 VDD.n7 VDD.n109 17.8732
R376 VDD.n6 VDD.n110 17.8699
R377 VDD.n148 VDD.n147 17.4025
R378 VDD.n153 VDD.n148 17.4025
R379 VDD.n174 VDD.n173 17.1127
R380 VDD.n89 VDD.n1 16.218
R381 VDD.n90 VDD.n89 15.8948
R382 VDD.n176 VDD.n17 15.4259
R383 VDD.n4 VDD.t94 15.1423
R384 VDD.n89 VDD.t23 15.1423
R385 VDD.t84 VDD.n95 14.2313
R386 VDD.n95 VDD.n79 14.2313
R387 VDD.t56 VDD.n0 14.2313
R388 VDD.n3 VDD.n0 14.2313
R389 VDD.n96 VDD.t84 14.2313
R390 VDD.n97 VDD.n96 14.2313
R391 VDD.t56 VDD.n91 14.2313
R392 VDD.n91 VDD.n90 14.2313
R393 VDD.n17 VDD.n15 12.9563
R394 VDD.n178 VDD.n176 12.6533
R395 VDD.n32 VDD.n28 12.3338
R396 VDD.n40 VDD.n39 12.3338
R397 VDD.n38 VDD.n26 12.3338
R398 VDD.n29 VDD.n27 12.3338
R399 VDD.n121 VDD.n21 12.3338
R400 VDD.n125 VDD.n124 12.3338
R401 VDD.n167 VDD.n156 12.2338
R402 VDD.n35 VDD.n34 10.8829
R403 VDD.n46 VDD.n45 10.8829
R404 VDD.n42 VDD.n41 10.8829
R405 VDD.n31 VDD.n25 10.8829
R406 VDD.n120 VDD.n98 10.8829
R407 VDD.n119 VDD.n118 10.8829
R408 VDD.n5 VDD.n171 10.6133
R409 VDD.n43 VDD.n38 10.589
R410 VDD.n30 VDD.n29 10.589
R411 VDD.n33 VDD.n32 10.589
R412 VDD.n44 VDD.n39 10.589
R413 VDD.n122 VDD.n121 10.589
R414 VDD.n124 VDD.n123 10.589
R415 VDD.n23 VDD.n80 10.5249
R416 VDD.t24 VDD.n18 0.396924
R417 VDD.n135 VDD.n21 9.82847
R418 VDD.n126 VDD.n125 9.64998
R419 VDD.n125 VDD.n99 9.64998
R420 VDD.n172 VDD.n5 9.03451
R421 VDD.n136 VDD.n75 8.81002
R422 VDD.n137 VDD.n136 8.81002
R423 VDD.n66 VDD.n64 8.81002
R424 VDD.n64 VDD.n61 8.81002
R425 VDD.n139 VDD.n65 8.81002
R426 VDD.n140 VDD.n139 8.81002
R427 VDD.n135 VDD.n134 8.49974
R428 VDD.n134 VDD.n13 8.46622
R429 VDD.n184 VDD.n183 8.40959
R430 VDD.n5 VDD.n58 8.40959
R431 VDD.n167 VDD.n166 8.40959
R432 VDD.n117 VDD.n99 8.23238
R433 VDD.n170 VDD.n51 8.04398
R434 VDD.t10 VDD.n182 8.04398
R435 VDD.n182 VDD.n181 8.04398
R436 VDD.n118 VDD.n21 7.58605
R437 VDD.n168 VDD.n20 7.42545
R438 VDD.n162 VDD.n59 7.41354
R439 VDD.n153 VDD.n152 7.16615
R440 VDD.n147 VDD.n74 7.16615
R441 VDD.n19 VDD.n62 7.15312
R442 VDD.n14 VDD.n184 7.10019
R443 VDD.t10 VDD.n51 7.04089
R444 VDD.n47 VDD.n26 7.00566
R445 VDD.n37 VDD.n36 6.12589
R446 VDD.n23 VDD.n97 5.89813
R447 VDD.t2 VDD.n55 5.60656
R448 VDD.n55 VDD.n54 5.60656
R449 VDD.t4 VDD.n11 5.60656
R450 VDD.n13 VDD.n11 5.60656
R451 VDD.n155 VDD.t7 5.60656
R452 VDD.n19 VDD.n155 5.60656
R453 VDD.n128 VDD.n13 5.60656
R454 VDD.n130 VDD.n129 5.60656
R455 VDD.n146 VDD.t4 5.60656
R456 VDD.n147 VDD.n146 5.60656
R457 VDD.t4 VDD.n145 5.60656
R458 VDD.n145 VDD.n144 5.60656
R459 VDD.t7 VDD.n67 5.60656
R460 VDD.n142 VDD.n67 5.60656
R461 VDD.t7 VDD.n154 5.60656
R462 VDD.n154 VDD.n153 5.60656
R463 VDD.t10 VDD.t24 5.5495
R464 VDD.n177 VDD.t25 5.5395
R465 VDD.n177 VDD.t54 5.5395
R466 VDD.n89 VDD.n88 5.37795
R467 VDD.n137 VDD.n135 5.3728
R468 VDD.t87 VDD.n131 5.13939
R469 VDD.n131 VDD.n62 5.13939
R470 VDD.n132 VDD.t87 5.13939
R471 VDD.n133 VDD.n132 5.13939
R472 VDD.n4 VDD.n10 5.12603
R473 VDD.n126 VDD.n98 5.03673
R474 VDD.n4 VDD.n22 4.4863
R475 VDD.n83 VDD.n79 4.42034
R476 VDD.n83 VDD.n3 4.42034
R477 VDD.n161 VDD.n57 4.40526
R478 VDD.n169 VDD.n57 4.40526
R479 VDD.n161 VDD.n160 4.40526
R480 VDD.n160 VDD.n159 4.40526
R481 VDD.n17 VDD.n16 4.30652
R482 VDD.n75 VDD.n2 4.30283
R483 VDD.n3 VDD.n2 4.30283
R484 VDD.n77 VDD.n65 4.30283
R485 VDD.n77 VDD.n71 4.30283
R486 VDD.n70 VDD.n66 4.30283
R487 VDD.n149 VDD.n70 4.30283
R488 VDD.n3 VDD.n1 4.27831
R489 VDD.n138 VDD.n137 4.20937
R490 VDD.n4 VDD.n23 4.07792
R491 VDD.n20 VDD.n19 4.0421
R492 VDD.n175 VDD.n174 3.85467
R493 VDD.n17 VDD.n175 3.85467
R494 VDD.n165 VDD.n164 3.85467
R495 VDD.n164 VDD.n163 3.85467
R496 VDD.n89 VDD.n85 3.85467
R497 VDD.n113 VDD.n100 3.85467
R498 VDD.n93 VDD.n92 3.85467
R499 VDD.n93 VDD.n84 3.85467
R500 VDD.n180 VDD.n179 3.85467
R501 VDD.n19 VDD.n12 3.8107
R502 VDD.n13 VDD.n12 3.8107
R503 VDD.n118 VDD.n117 3.75702
R504 VDD.n163 VDD.n162 3.43963
R505 VDD.n138 VDD.n79 3.28405
R506 VDD.n134 VDD.n98 3.23459
R507 VDD VDD.n14 3.19533
R508 VDD.n135 VDD.n23 3.15828
R509 VDD.n168 VDD.n167 3.14804
R510 VDD.t63 VDD.n115 3.08383
R511 VDD.n115 VDD.n114 3.08383
R512 VDD.n116 VDD.t63 3.08383
R513 VDD.n117 VDD.n116 3.08383
R514 VDD.n161 VDD.t2 3.06269
R515 VDD.n151 VDD.t73 2.77
R516 VDD.n151 VDD.t74 2.77
R517 VDD.n150 VDD.t71 2.77
R518 VDD.n150 VDD.t72 2.77
R519 VDD.n73 VDD.t69 2.77
R520 VDD.n73 VDD.t58 2.77
R521 VDD.n72 VDD.t90 2.77
R522 VDD.n72 VDD.t68 2.77
R523 VDD.n53 VDD.t53 2.77
R524 VDD.n53 VDD.t55 2.77
R525 VDD.n28 VDD.n24 2.66717
R526 VDD.n184 VDD.n49 2.61617
R527 VDD.n112 VDD.t92 1.84683
R528 VDD.n112 VDD.t15 1.84683
R529 VDD.n111 VDD.t32 1.84683
R530 VDD.n111 VDD.t1 1.84683
R531 VDD.n110 VDD.t60 1.84683
R532 VDD.n110 VDD.t27 1.84683
R533 VDD.n109 VDD.t9 1.84683
R534 VDD.n109 VDD.t12 1.84683
R535 VDD.n108 VDD.t62 1.84683
R536 VDD.n108 VDD.t77 1.84683
R537 VDD.n107 VDD.t89 1.84683
R538 VDD.n107 VDD.t83 1.84683
R539 VDD.n106 VDD.t64 1.84683
R540 VDD.n106 VDD.t17 1.84683
R541 VDD.n105 VDD.t38 1.84683
R542 VDD.n105 VDD.t34 1.84683
R543 VDD.n104 VDD.t42 1.84683
R544 VDD.n104 VDD.t66 1.84683
R545 VDD.n103 VDD.t19 1.84683
R546 VDD.n103 VDD.t80 1.84683
R547 VDD.n102 VDD.t40 1.84683
R548 VDD.n102 VDD.t36 1.84683
R549 VDD.n101 VDD.t44 1.84683
R550 VDD.n101 VDD.t86 1.84683
R551 VDD.n87 VDD.t57 1.84683
R552 VDD.n87 VDD.t6 1.84683
R553 VDD.n86 VDD.t97 1.84683
R554 VDD.n86 VDD.t99 1.84683
R555 VDD.n97 VDD.n81 1.82072
R556 VDD.n90 VDD.n81 1.82072
R557 VDD.n7 VDD.n6 1.7505
R558 VDD.n8 VDD.n7 1.73579
R559 VDD.n33 VDD.t49 1.69257
R560 VDD.t51 VDD.n43 1.69257
R561 VDD.n30 VDD.t49 1.69257
R562 VDD.n44 VDD.t51 1.69257
R563 VDD.n123 VDD.t28 1.69257
R564 VDD.t28 VDD.n122 1.69257
R565 VDD.n62 VDD.n60 1.28599
R566 VDD.n9 VDD.n8 1.1641
R567 VDD.n10 VDD.n9 1.15307
R568 GND.n193 GND.n192 63145.3
R569 GND.n194 GND.n193 28534.7
R570 GND.n192 GND.n30 24264
R571 GND.n191 GND.n189 13575.1
R572 GND.n169 GND.n51 10975.9
R573 GND.n165 GND.n67 10975.9
R574 GND.n166 GND.n67 10975.9
R575 GND.n168 GND.n51 10975.9
R576 GND.n159 GND.n76 9951.76
R577 GND.n159 GND.n77 9951.76
R578 GND.n140 GND.n95 9951.76
R579 GND.n139 GND.n95 9951.76
R580 GND.n194 GND.n28 8624.43
R581 GND.n58 GND.n53 8183.36
R582 GND.n61 GND.n53 8183.36
R583 GND.n61 GND.n54 8183.36
R584 GND.n58 GND.n54 8183.36
R585 GND.n170 GND.n12 6023.09
R586 GND.n121 GND.n12 6023.09
R587 GND.n121 GND.n6 6023.09
R588 GND.n170 GND.n6 6023.09
R589 GND.n11 GND.n73 6023.09
R590 GND.n163 GND.n11 6023.09
R591 GND.n164 GND.n163 6023.09
R592 GND.n164 GND.n73 6023.09
R593 GND.n86 GND.n85 6023.09
R594 GND.n89 GND.n86 6023.09
R595 GND.n143 GND.n141 5657.55
R596 GND.n143 GND.n94 5657.55
R597 GND.n66 GND.n52 5631.21
R598 GND.n167 GND.n66 5631.21
R599 GND.n188 GND.n31 5581.81
R600 GND.n34 GND.n31 5581.81
R601 GND.n34 GND.n32 5581.81
R602 GND.n188 GND.n32 5581.81
R603 GND.n154 GND.n82 5443.5
R604 GND.n145 GND.n82 5443.5
R605 GND.n196 GND.n25 5364.47
R606 GND.n27 GND.n25 5364.47
R607 GND.n196 GND.n24 5364.47
R608 GND.n27 GND.n24 5364.47
R609 GND.n165 GND.n52 5344.71
R610 GND.n169 GND.n52 5344.71
R611 GND.n167 GND.n166 5344.71
R612 GND.n168 GND.n167 5344.71
R613 GND.n195 GND.n194 4812.92
R614 GND.n190 GND.n29 4521.13
R615 GND.n149 GND.n0 4376.53
R616 GND.n129 GND.n102 4376.53
R617 GND.n190 GND.n30 4348.47
R618 GND.n136 GND.n98 4346.9
R619 GND.n136 GND.n99 4346.9
R620 GND.n107 GND.n1 4346.9
R621 GND.n146 GND.n1 4346.9
R622 GND.n139 GND.n94 4294.21
R623 GND.n94 GND.n76 4294.21
R624 GND.n141 GND.n140 4294.21
R625 GND.n141 GND.n77 4294.21
R626 GND.n193 GND.n29 4219.24
R627 GND.n182 GND.n38 3935.26
R628 GND.n182 GND.n17 31.777
R629 GND.n174 GND.n47 3935.26
R630 GND.n173 GND.n47 3935.26
R631 GND.n89 GND.n87 3230.53
R632 GND.n180 GND.n42 3223.95
R633 GND.n180 GND.n179 3223.95
R634 GND.n179 GND.n41 3223.95
R635 GND.n42 GND.n41 3223.95
R636 GND.n85 GND.n83 3158.09
R637 GND.n152 GND.n83 2865
R638 GND.n152 GND.n87 2792.55
R639 GND.n149 GND.n88 2650.95
R640 GND.n129 GND.n104 2650.95
R641 GND.n154 GND.n83 2614.72
R642 GND.n145 GND.n87 2614.72
R643 GND.n103 GND.n98 2614.72
R644 GND.n104 GND.n99 2614.72
R645 GND.n110 GND.n107 2614.72
R646 GND.n146 GND.n88 2614.72
R647 GND.n176 GND.n44 2282.12
R648 GND.n176 GND.n43 2282.12
R649 GND.n112 GND.n102 2282.12
R650 GND.n112 GND.n0 2282.12
R651 GND.n115 GND.n112 2094.41
R652 GND.n115 GND.n111 2094.41
R653 GND.n135 GND.n103 1738.76
R654 GND.n110 GND.n109 1738.76
R655 GND.n135 GND.n104 1725.59
R656 GND.n109 GND.n88 1725.59
R657 GND.n43 GND.n38 1653.14
R658 GND.n174 GND.n44 1653.14
R659 GND.n44 GND.n39 1653.14
R660 GND.n173 GND.n43 1653.14
R661 GND.n74 GND.n29 1510.94
R662 GND.n191 GND.n190 1298.75
R663 GND.n192 GND.n191 1123.32
R664 GND.n125 GND.n120 760.847
R665 GND.n189 GND.n30 748.25
R666 GND.t46 GND.n72 738.26
R667 GND.t39 GND.n65 706.042
R668 GND.n63 GND.n62 696.553
R669 GND.n130 GND.n127 686.933
R670 GND.n20 GND.n144 661.736
R671 GND.n144 GND.n93 651.294
R672 GND.n124 GND.n10 648.471
R673 GND.n68 GND.n4 648.283
R674 GND.n69 GND.n68 648.283
R675 GND.t38 GND.n71 580.467
R676 GND.n111 GND.n103 543.362
R677 GND.n111 GND.n110 543.362
R678 GND.t0 GND.n195 462.421
R679 GND.t0 GND.n26 462.421
R680 GND.n162 GND.n74 424.728
R681 GND.n127 GND.n126 418.579
R682 GND.n138 GND.n14 91.6696
R683 GND.n184 GND.n35 410.17
R684 GND.t47 GND.n3 403.007
R685 GND.t45 GND.n84 399.743
R686 GND.n161 GND.n160 364.861
R687 GND.n151 GND.n81 322.675
R688 GND.n151 GND.n150 312.848
R689 GND.n119 GND.n118 295.68
R690 GND.n118 GND.n117 295.68
R691 GND.n153 GND.t14 282.366
R692 GND.n158 GND.n79 273.341
R693 GND.n181 GND.n40 262.743
R694 GND.n71 GND.n70 256.904
R695 GND.n70 GND.n65 256.904
R696 GND.n175 GND.n16 254.494
R697 GND.n175 GND.n46 254.494
R698 GND.n108 GND.n18 250.781
R699 GND.t35 GND.n101 247.012
R700 GND.t2 GND.n96 247.012
R701 GND.n147 GND.t36 247.012
R702 GND.n116 GND.n105 244.552
R703 GND.n118 GND.n116 243.953
R704 GND.t48 GND.n64 222.493
R705 GND.n113 GND.n100 212.129
R706 GND.n148 GND.n90 210.714
R707 GND.n162 GND.n161 201.286
R708 GND.n128 GND.n28 192.802
R709 GND.n108 GND.n105 192.376
R710 GND.n134 GND.n105 192.376
R711 GND.n134 GND.n133 191.095
R712 GND.n160 GND.n75 180.073
R713 GND.n5 GND.n72 153.988
R714 GND.n153 GND.n75 152.262
R715 GND.n74 GND.t43 137.648
R716 GND.t4 GND.n47 134.101
R717 GND.n5 GND.n4 125.906
R718 GND.n7 GND.n4 125.906
R719 GND.n28 GND.n26 123.477
R720 GND.t14 GND.t37 122.564
R721 GND.n127 GND.t42 117.76
R722 GND.n10 GND.n7 116.522
R723 GND.n19 GND.n20 18.825
R724 GND.n125 GND.t44 110.052
R725 GND.n64 GND.n63 104.436
R726 GND.n177 GND.t16 101.6
R727 GND.t12 GND.n177 101.6
R728 GND.n62 GND.t29 101.6
R729 GND.n59 GND.n55 92.9388
R730 GND.n142 GND.n84 87.2086
R731 GND.n9 GND.n78 83.4527
R732 GND.n60 GND.n59 82.9338
R733 GND.n128 GND.n101 79.6662
R734 GND.n148 GND.n147 79.6662
R735 GND.n114 GND.n113 77.7807
R736 GND.n114 GND.n96 77.7807
R737 GND.n142 GND.n90 75.4237
R738 GND.t13 GND.t4 74.6649
R739 GND.t17 GND.t50 74.6649
R740 GND.t50 GND.t16 74.6649
R741 GND.t8 GND.t31 74.6649
R742 GND.t31 GND.t9 74.6649
R743 GND.t9 GND.t34 74.6649
R744 GND.t30 GND.t29 74.6649
R745 GND.t10 GND.t30 74.6649
R746 GND.t18 GND.t10 74.6649
R747 GND.t33 GND.t18 74.6649
R748 GND.t15 GND.t33 74.6649
R749 GND.t20 GND.t15 74.6649
R750 GND.t21 GND.t20 74.6649
R751 GND.t19 GND.t21 74.6649
R752 GND.t22 GND.t19 74.6649
R753 GND.t23 GND.t22 74.6649
R754 GND.t25 GND.t23 74.6649
R755 GND.t26 GND.t25 74.6649
R756 GND.t24 GND.t26 74.6649
R757 GND.t32 GND.t24 74.6649
R758 GND.t27 GND.t7 74.6649
R759 GND.t7 GND.t6 74.6649
R760 GND.t6 GND.t3 74.6649
R761 GND.t3 GND.t28 74.6649
R762 GND.n179 GND.n178 73.1255
R763 GND.n179 GND.t41 73.1255
R764 GND.n42 GND.n40 73.1255
R765 GND.n48 GND.n42 73.1255
R766 GND.n137 GND.n136 59.1188
R767 GND.t17 GND.n171 58.5979
R768 GND.n39 GND.n17 55.8877
R769 GND.n138 GND.n93 53.8431
R770 GND.n93 GND.n78 53.8431
R771 GND.n56 GND.t32 52.4546
R772 GND.n57 GND.t27 52.4546
R773 GND.n181 GND.t40 51.5095
R774 GND.t40 GND.t34 50.0918
R775 GND.n126 GND.n23 49.6054
R776 GND.n57 GND.n56 49.1467
R777 GND.t28 GND.n30 49.1467
R778 GND.n187 GND.n186 47.7277
R779 GND.n180 GND.n15 46.5723
R780 GND.n187 GND.n33 46.3725
R781 GND.n130 GND.n129 46.2937
R782 GND.n81 GND.n80 46.1581
R783 GND.t36 GND.n1 45.0005
R784 GND.n21 GND.n1 45.0005
R785 GND.n136 GND.t35 45.0005
R786 GND.t6 GND.n32 45.0005
R787 GND.n186 GND.n32 45.0005
R788 GND.t6 GND.n31 45.0005
R789 GND.n33 GND.n31 45.0005
R790 GND.n174 GND.t17 45.0005
R791 GND.n16 GND.n174 45.0005
R792 GND.t17 GND.n173 45.0005
R793 GND.n173 GND.n172 45.0005
R794 GND.t31 GND.n39 45.0005
R795 GND.t31 GND.n38 45.0005
R796 GND.n45 GND.n38 45.0005
R797 GND.n163 GND.n72 42.5615
R798 GND.n85 GND.n72 42.5512
R799 GND.n14 GND.n13 36.4633
R800 GND.n178 GND.t8 40.168
R801 GND.n130 GND.n24 38.303
R802 GND.t35 GND.n100 35.8265
R803 GND.n126 GND.n125 34.7889
R804 GND.n170 GND.n10 34.5553
R805 GND.n178 GND.t12 34.4973
R806 GND.n129 GND.n128 34.4123
R807 GND.n115 GND.n114 34.4123
R808 GND.n116 GND.n115 34.4123
R809 GND.n149 GND.n148 34.4123
R810 GND.n3 GND.n149 34.4123
R811 GND.n90 GND.n89 34.4123
R812 GND.n89 GND.n3 34.4123
R813 GND.n85 GND.n75 34.4123
R814 GND.n163 GND.n162 34.4123
R815 GND.n73 GND.n71 34.4123
R816 GND.n122 GND.n73 34.4123
R817 GND.n121 GND.n65 34.4123
R818 GND.n122 GND.n121 34.4123
R819 GND.t40 GND.n41 34.4123
R820 GND.n49 GND.n41 34.4123
R821 GND.t40 GND.n180 34.4123
R822 GND.n171 GND.n170 34.4123
R823 GND.t35 GND.n102 33.4433
R824 GND.t0 GND.n27 32.5005
R825 GND.n131 GND.n27 32.5005
R826 GND.n196 GND.t0 32.5005
R827 GND.t1 GND.n196 32.5005
R828 GND.t36 GND.n0 32.5005
R829 GND.n117 GND.n0 32.5005
R830 GND.n119 GND.n102 32.5005
R831 GND.n109 GND.t36 32.5005
R832 GND.n109 GND.n108 32.5005
R833 GND.t35 GND.n135 32.5005
R834 GND.n135 GND.n134 32.5005
R835 GND.n47 GND.t5 32.5005
R836 GND.n177 GND.n176 32.5005
R837 GND.n176 GND.n175 32.5005
R838 GND.n182 GND.n181 32.5005
R839 GND.n15 GND.n17 0.46255
R840 GND.n55 GND.n33 31.8869
R841 GND.n155 GND.n81 31.0692
R842 GND.n156 GND.n79 30.4748
R843 GND.n123 GND.t49 29.904
R844 GND.n156 GND.n155 29.1274
R845 GND.n106 GND.n105 28.9412
R846 GND.t49 GND.n10 28.6998
R847 GND.n106 GND.n97 28.3434
R848 GND.n101 GND.n99 26.5914
R849 GND.n133 GND.n99 26.5914
R850 GND.n147 GND.n146 26.5914
R851 GND.n107 GND.n96 26.5914
R852 GND.n107 GND.n106 26.5914
R853 GND.n113 GND.n98 26.5914
R854 GND.n106 GND.n98 26.5914
R855 GND.n145 GND.n84 26.5914
R856 GND.n18 GND.n145 26.5914
R857 GND.n154 GND.n153 26.5914
R858 GND.n155 GND.n154 26.5914
R859 GND.t44 GND.n124 25.9315
R860 GND.t37 GND.n82 25.4353
R861 GND.n92 GND.n82 25.4353
R862 GND.n19 GND.n18 0.41545
R863 GND.n195 GND.n25 22.5005
R864 GND.n25 GND.n22 22.5005
R865 GND.n26 GND.n24 22.5005
R866 GND.n9 GND.n8 21.4226
R867 GND.n186 GND.n185 20.3144
R868 GND.t11 GND.n60 20.3061
R869 GND.n185 GND.n34 17.8802
R870 GND.t45 GND.n86 17.7278
R871 GND.n120 GND.n86 17.7278
R872 GND.t45 GND.n152 17.7278
R873 GND.n152 GND.n151 17.7278
R874 GND.n11 GND.t43 17.7278
R875 GND.n164 GND.t43 17.7278
R876 GND.n5 GND.n164 17.7278
R877 GND.t48 GND.n12 17.7278
R878 GND.t48 GND.n6 17.7278
R879 GND.n7 GND.n6 17.7278
R880 GND.n56 GND.n34 17.7278
R881 GND.n62 GND.n61 17.7278
R882 GND.n61 GND.t11 17.7278
R883 GND.n58 GND.n57 17.7278
R884 GND.n59 GND.n58 17.7278
R885 GND.n189 GND.n188 17.7278
R886 GND.n188 GND.n187 17.7278
R887 GND.n8 GND.n69 17.2981
R888 GND.n69 GND.n35 17.2981
R889 GND.n133 GND.n132 16.9486
R890 GND.n80 GND.n72 16.5241
R891 GND.t14 GND.n77 16.2505
R892 GND.n91 GND.n77 16.2505
R893 GND.n140 GND.t2 16.2505
R894 GND.n140 GND.n21 16.2505
R895 GND.t14 GND.n76 16.2505
R896 GND.n78 GND.n76 16.2505
R897 GND.t2 GND.n139 16.2505
R898 GND.n139 GND.n138 16.2505
R899 GND.n171 GND.t13 16.0675
R900 GND.t21 GND.n54 15.8113
R901 GND.n54 GND.n37 15.8113
R902 GND.t21 GND.n53 15.8113
R903 GND.n60 GND.n53 15.8113
R904 GND.n156 GND.n80 15.7262
R905 GND.n183 GND.n36 14.7049
R906 GND.n14 GND.n95 13.1142
R907 GND.n131 GND.n22 13.1789
R908 GND.t38 GND.n165 13.0005
R909 GND.n166 GND.t38 13.0005
R910 GND.n166 GND.n8 13.0005
R911 GND.n169 GND.t39 13.0005
R912 GND.t39 GND.n168 13.0005
R913 GND.n168 GND.n35 13.0005
R914 GND.n158 GND.n157 12.9403
R915 GND.n150 GND.n18 12.723
R916 GND.n172 GND.t5 12.6197
R917 GND.n100 GND.n95 11.9393
R918 GND.n143 GND.n142 11.9393
R919 GND.n144 GND.n143 11.9393
R920 GND.n160 GND.n159 11.9393
R921 GND.n159 GND.n9 11.9393
R922 GND.n161 GND.n67 11.9393
R923 GND.n157 GND.n67 11.9393
R924 GND.n70 GND.n66 11.9393
R925 GND.n68 GND.n66 11.9393
R926 GND.n63 GND.n51 11.9393
R927 GND.n51 GND.n36 11.9393
R928 GND.n130 GND.n23 11.7676
R929 GND.n64 GND.n40 10.8694
R930 GND.n13 GND.n137 9.97259
R931 GND.n123 GND.n122 9.2165
R932 GND.n122 GND.n4 8.9605
R933 GND GND.n22 8.71484
R934 GND.n120 GND.t46 8.65932
R935 GND.n185 GND.n184 8.6584
R936 GND.n49 GND.n48 8.52832
R937 GND.n132 GND.n131 8.51375
R938 GND.n50 GND.n49 8.39564
R939 GND GND.t1 8.13792
R940 GND.n184 GND.n183 7.73513
R941 GND.n20 GND.n92 7.62369
R942 GND.n183 GND.n2 7.5239
R943 GND.n45 GND.n2 7.08424
R944 GND.n97 GND.n21 6.452
R945 GND.n20 GND.n21 6.07105
R946 GND.n55 GND.n37 6.00172
R947 GND.t41 GND.n15 5.63962
R948 GND.n137 GND.n97 5.60641
R949 GND.n2 GND.n15 5.52998
R950 GND.n91 GND.n79 5.33307
R951 GND.t37 GND.t45 5.18584
R952 GND.n183 GND.n37 4.4309
R953 GND.n50 GND.t41 4.43085
R954 GND.t42 GND.n119 4.26717
R955 GND.n117 GND.t47 4.26717
R956 GND.n124 GND.n123 3.97291
R957 GND.n157 GND.n156 2.79714
R958 GND.n146 GND.n19 28.5882
R959 GND.t49 GND.n12 17.8381
R960 GND.t44 GND.n11 17.8381
R961 GND.n150 GND.n3 17.508
R962 GND.n7 GND.n169 13.2332
R963 GND.n165 GND.n5 13.2332
R964 GND.n16 GND.t5 8.66743
R965 GND.n9 GND.n158 8.44703
R966 GND.t1 GND.n23 7.49669
R967 GND.t11 GND.n2 5.78871
R968 GND.n132 GND.n13 5.61287
R969 GND.n16 GND.n15 3.9685
R970 GND.n10 GND.n50 2.79203
R971 GND.n92 GND.n91 2.38275
R972 GND.n172 GND.n46 2.25558
R973 GND.n46 GND.n45 2.25558
R974 GND.n48 GND.n36 1.90489
R975 GND.t2 GND.t36 1.88608
R976 GND.t39 GND.t48 1.78044
R977 GND.t38 GND.t43 1.41468
R978 GND.n132 GND.n130 1.11984
R979 a_40258_n12.n7 a_40258_n12.t9 154.666
R980 a_40258_n12.n7 a_40258_n12.n10 110.181
R981 a_40258_n12.n2 a_40258_n12.n1 116.668
R982 a_40258_n12.n2 a_40258_n12.t7 154.969
R983 a_40258_n12.n3 a_40258_n12.t5 154.969
R984 a_40258_n12.n3 a_40258_n12.n12 109.576
R985 a_40258_n12.n6 a_40258_n12.n5 110.016
R986 a_40258_n12.n6 a_40258_n12.t3 156.155
R987 a_40258_n12.n2 a_40258_n12.n11 109.576
R988 a_40258_n12.n13 a_40258_n12.n6 107.204
R989 a_40258_n12.n22 a_40258_n12.n9 202.542
R990 a_40258_n12.n20 a_40258_n12.n15 202.542
R991 a_40258_n12.n22 a_40258_n12.n21 201.788
R992 a_40258_n12.n13 a_40258_n12.n0 198.475
R993 a_40258_n12.n19 a_40258_n12.n15 196.625
R994 a_40258_n12.n21 a_40258_n12.t11 137.951
R995 a_40258_n12.t11 a_40258_n12.n9 129.388
R996 a_40258_n12.n8 a_40258_n12.n1 39.4058
R997 a_40258_n12.n4 a_40258_n12.n5 39.0153
R998 a_40258_n12.n21 a_40258_n12.n8 16.8783
R999 a_40258_n12.n0 a_40258_n12.n5 222.931
R1000 a_40258_n12.n10 a_40258_n12.n11 39.8816
R1001 a_40258_n12.n12 a_40258_n12.n13 37.0271
R1002 a_40258_n12.n3 a_40258_n12.n4 116.681
R1003 a_40258_n12.n8 a_40258_n12.n7 113.79
R1004 a_40258_n12.n20 a_40258_n12.n1 16.742
R1005 a_40258_n12.n20 a_40258_n12.n4 16.9539
R1006 a_40258_n12.n10 a_40258_n12.n9 19.4467
R1007 a_40258_n12.n0 a_40258_n12.t2 17.1851
R1008 a_40258_n12.n18 a_40258_n12.n17 16.6079
R1009 a_40258_n12.n0 a_40258_n12.t4 16.5208
R1010 a_40258_n12.n12 a_40258_n12.n19 16.5166
R1011 a_40258_n12.n19 a_40258_n12.n11 16.3102
R1012 a_40258_n12.n18 a_40258_n12.n16 15.6267
R1013 a_40258_n12.t10 a_40258_n12.n22 13.2148
R1014 a_40258_n12.n15 a_40258_n12.n14 13.2148
R1015 a_40258_n12.t12 a_40258_n12.t10 3.3065
R1016 a_40258_n12.n14 a_40258_n12.t8 3.3065
R1017 a_40258_n12.n14 a_40258_n12.t6 3.3065
R1018 a_40258_n12.n17 a_40258_n12.t1 3.3065
R1019 a_40258_n12.n17 a_40258_n12.t14 3.3065
R1020 a_40258_n12.n16 a_40258_n12.t0 3.3065
R1021 a_40258_n12.n16 a_40258_n12.t13 3.3065
R1022 a_40258_n12.n0 a_40258_n12.n18 2.35393
R1023 Vg28.n36 Vg28.n35 228.623
R1024 Vg28.n34 Vg28.n33 228.623
R1025 Vg28.n18 Vg28.n17 228.623
R1026 Vg28.n16 Vg28.n15 228.623
R1027 Vg28.n14 Vg28.n13 228.623
R1028 Vg28.n12 Vg28.n11 228.623
R1029 Vg28.n10 Vg28.n9 228.623
R1030 Vg28.n8 Vg28.n7 228.623
R1031 Vg28.n6 Vg28.n5 228.623
R1032 Vg28.n4 Vg28.n26 228.623
R1033 Vg28.n39 Vg28.n32 228.623
R1034 Vg28.n31 Vg28.n40 228.623
R1035 Vg28.n28 Vg28.n42 228.623
R1036 Vg28.t28 Vg28.n1 215.857
R1037 Vg28.n0 Vg28.n1 228.798
R1038 Vg28.t29 Vg28.n36 215.946
R1039 Vg28.n37 Vg28.n36 228.623
R1040 Vg28.n33 Vg28.t30 215.946
R1041 Vg28.n33 Vg28.n38 228.623
R1042 Vg28.t31 Vg28.n18 215.946
R1043 Vg28.n19 Vg28.n18 228.623
R1044 Vg28.n15 Vg28.t32 215.946
R1045 Vg28.n15 Vg28.n20 228.623
R1046 Vg28.t33 Vg28.n14 215.946
R1047 Vg28.n21 Vg28.n14 228.623
R1048 Vg28.n11 Vg28.t34 215.946
R1049 Vg28.n11 Vg28.n22 228.623
R1050 Vg28.t35 Vg28.n10 215.946
R1051 Vg28.n23 Vg28.n10 228.623
R1052 Vg28.n7 Vg28.t36 215.946
R1053 Vg28.n7 Vg28.n24 228.623
R1054 Vg28.t37 Vg28.n6 215.946
R1055 Vg28.n25 Vg28.n6 228.623
R1056 Vg28.n3 Vg28.n4 228.623
R1057 Vg28.t38 Vg28.n4 215.946
R1058 Vg28.n32 Vg28.n29 228.623
R1059 Vg28.n32 Vg28.t39 215.946
R1060 Vg28.n31 Vg28.n30 228.623
R1061 Vg28.n31 Vg28.t40 215.946
R1062 Vg28.n27 Vg28.n28 228.623
R1063 Vg28.t41 Vg28.n28 215.946
R1064 Vg28.n42 Vg28.n41 257.466
R1065 Vg28.n27 Vg28.n41 254.756
R1066 Vg28.n41 Vg28.t42 215.746
R1067 Vg28.n5 Vg28.n3 30.1602
R1068 Vg28.n35 Vg28.n34 29.6679
R1069 Vg28.n30 Vg28.n27 29.6679
R1070 Vg28.n3 Vg28.n29 29.6679
R1071 Vg28.n30 Vg28.n29 29.6679
R1072 Vg28.n17 Vg28.n16 29.6679
R1073 Vg28.n16 Vg28.n13 29.6679
R1074 Vg28.n13 Vg28.n12 29.6679
R1075 Vg28.n12 Vg28.n9 29.6679
R1076 Vg28.n9 Vg28.n8 29.6679
R1077 Vg28.n8 Vg28.n5 29.6679
R1078 Vg28.n35 Vg28.n1 258.3
R1079 Vg28.n34 Vg28.n17 29.3397
R1080 Vg28.n38 Vg28.n19 28.6481
R1081 Vg28.n39 Vg28.n40 28.6481
R1082 Vg28.n26 Vg28.n39 28.4957
R1083 Vg28.n0 Vg28.n37 28.4957
R1084 Vg28.n25 Vg28.n26 28.4957
R1085 Vg28.n24 Vg28.n25 28.4957
R1086 Vg28.n23 Vg28.n24 28.4957
R1087 Vg28.n22 Vg28.n23 28.4957
R1088 Vg28.n21 Vg28.n22 28.4957
R1089 Vg28.n20 Vg28.n21 28.4957
R1090 Vg28.n19 Vg28.n20 28.4957
R1091 Vg28.n37 Vg28.n38 28.3434
R1092 Vg28.n42 Vg28.n40 28.3434
R1093 Vg28.n50 Vg28.n48 24.7495
R1094 Vg28.n2 Vg28.t7 24.6374
R1095 Vg28.n60 Vg28.n59 23.698
R1096 Vg28.n58 Vg28.n57 23.698
R1097 Vg28.n56 Vg28.n55 23.698
R1098 Vg28.n54 Vg28.n53 23.698
R1099 Vg28.n52 Vg28.n51 23.698
R1100 Vg28.n50 Vg28.n49 23.698
R1101 m28_0.G Vg28.n0 16.278
R1102 Vg28.n46 Vg28.t9 11.0512
R1103 Vg28.n64 Vg28.n63 10.9879
R1104 Vg28.n45 Vg28.n44 10.6012
R1105 Vg28.n45 Vg28.n43 9.78093
R1106 Vg28.n64 Vg28.n62 8.79046
R1107 Vg28.n65 Vg28.n61 8.79012
R1108 Vg28.n2 Vg28.t20 5.88662
R1109 m28_0.G Vg28.t27 3.11635
R1110 M17_18.D Vg28.n2 2.99946
R1111 Vg28.n59 Vg28.t5 2.77
R1112 Vg28.n59 Vg28.t4 2.77
R1113 Vg28.n57 Vg28.t1 2.77
R1114 Vg28.n57 Vg28.t6 2.77
R1115 Vg28.n55 Vg28.t15 2.77
R1116 Vg28.n55 Vg28.t8 2.77
R1117 Vg28.n53 Vg28.t10 2.77
R1118 Vg28.n53 Vg28.t12 2.77
R1119 Vg28.n51 Vg28.t16 2.77
R1120 Vg28.n51 Vg28.t19 2.77
R1121 Vg28.n49 Vg28.t17 2.77
R1122 Vg28.n49 Vg28.t18 2.77
R1123 Vg28.n48 Vg28.t13 2.77
R1124 Vg28.n48 Vg28.t14 2.77
R1125 Vg28.n2 Vg28.n47 2.67537
R1126 Vg28.n2 Vg28.n60 2.30491
R1127 Vg28.n65 Vg28.n64 2.20723
R1128 M17_18.D Vg28.n65 2.20242
R1129 Vg28.n44 Vg28.t0 1.6535
R1130 Vg28.n44 Vg28.t11 1.6535
R1131 Vg28.n43 Vg28.t3 1.6535
R1132 Vg28.n43 Vg28.t2 1.6535
R1133 Vg28.n47 m28_0.G 1.44752
R1134 Vg28.n47 Vg28.n46 1.34921
R1135 Vg28.n46 Vg28.n45 1.17994
R1136 Vg28.n63 Vg28.t26 1.15644
R1137 Vg28.n63 Vg28.t25 1.15644
R1138 Vg28.n62 Vg28.t24 1.15644
R1139 Vg28.n62 Vg28.t23 1.15644
R1140 Vg28.n61 Vg28.t22 1.15644
R1141 Vg28.n61 Vg28.t21 1.15644
R1142 Vg28.n58 Vg28.n56 1.05197
R1143 Vg28.n56 Vg28.n54 1.03726
R1144 Vg28.n60 Vg28.n58 1.02991
R1145 Vg28.n54 Vg28.n52 1.02991
R1146 Vg28.n52 Vg28.n50 1.02991
R1147 Vd24.n33 Vd24.n13 781.553
R1148 Vd24.n9 Vd24.n14 245.52
R1149 Vd24.n32 Vd24.n28 781.553
R1150 Vd24.t10 Vd24.n12 207.47
R1151 Vd24.n11 Vd24.n12 245.573
R1152 Vd24.t11 Vd24.n34 660.51
R1153 Vd24.n35 Vd24.t11 660.51
R1154 Vd24.n8 Vd24.n9 245.52
R1155 Vd24.t12 Vd24.n9 207.496
R1156 Vd24.t13 Vd24.n30 660.51
R1157 Vd24.n31 Vd24.t13 660.51
R1158 Vd24.n4 Vd24.n5 110.016
R1159 Vd24.t0 Vd24.n5 156.155
R1160 Vd24.n0 Vd24.n1 116.668
R1161 Vd24.t4 Vd24.n1 154.969
R1162 Vd24.t2 Vd24.n2 154.969
R1163 Vd24.n17 Vd24.n2 109.576
R1164 Vd24.t6 Vd24.n7 154.666
R1165 Vd24.n10 Vd24.n7 110.181
R1166 Vd24.n6 Vd24.n7 113.79
R1167 Vd24.n1 Vd24.n16 109.576
R1168 Vd24.n5 Vd24.n18 107.204
R1169 Vd24.n30 Vd24.n29 277.62
R1170 Vd24.n31 Vd24.n29 275.582
R1171 Vd24.n29 Vd24.t14 214.056
R1172 Vd24.n26 Vd24.n20 202.542
R1173 Vd24.n23 Vd24.n22 202.542
R1174 Vd24.n25 Vd24.n22 201.788
R1175 Vd24.n27 Vd24.n18 198.475
R1176 Vd24.n20 Vd24.n15 196.625
R1177 Vd24.n24 Vd24.t8 154.805
R1178 Vd24.n25 Vd24.n24 137.951
R1179 Vd24.n24 Vd24.n23 129.388
R1180 Vd24.n0 Vd24.n6 39.4058
R1181 Vd24.n3 Vd24.n4 39.0153
R1182 Vd24.n25 Vd24.n6 16.8783
R1183 Vd24.n34 Vd24.n12 290.8
R1184 Vd24.n33 Vd24.n8 43.8938
R1185 Vd24.n8 Vd24.n28 43.8938
R1186 Vd24.n11 Vd24.n35 43.1759
R1187 Vd24.n14 Vd24.n32 41.9451
R1188 Vd24.n14 Vd24.n13 41.9451
R1189 Vd24.n27 Vd24.n4 222.931
R1190 Vd24.n16 Vd24.n10 39.8816
R1191 Vd24.n18 Vd24.n17 37.0271
R1192 Vd24.n3 Vd24.n2 116.681
R1193 Vd24.n26 Vd24.n0 16.742
R1194 Vd24.n3 Vd24.n26 16.9539
R1195 Vd24 Vd24.n11 23.7965
R1196 Vd24.n23 Vd24.n10 19.4467
R1197 Vd24.n27 Vd24.t1 16.5208
R1198 Vd24.n17 Vd24.n15 16.5166
R1199 Vd24.n16 Vd24.n15 16.3102
R1200 Vd24.n20 Vd24.n19 13.2148
R1201 Vd24.n22 Vd24.n21 13.2148
R1202 Vd24.n19 Vd24.t5 3.3065
R1203 Vd24.n19 Vd24.t3 3.3065
R1204 Vd24.n21 Vd24.t9 3.3065
R1205 Vd24.n21 Vd24.t7 3.3065
R1206 Vd24 Vd24.n27 1.8946
R1207 Vd24.n30 Vd24.n28 1.33383
R1208 Vd24.n34 Vd24.n33 1.33383
R1209 Vd24.n35 Vd24.n13 1.23127
R1210 Vd24.n32 Vd24.n31 1.23127
R1211 Vg22.n13 Vg22.n23 320.106
R1212 Vg22.n13 Vg22.n12 320.106
R1213 Vg22.n13 Vg22.t6 292.873
R1214 Vg22.n5 Vg22.n6 238.644
R1215 Vg22.n28 Vg22.t11 228.147
R1216 Vg22.n6 Vg22.t12 213.103
R1217 Vg22.n6 Vg22.n8 238.644
R1218 Vg22.t14 Vg22.n22 227.982
R1219 Vg22.n24 Vg22.n22 208.887
R1220 Vg22.n44 Vg22.t15 664.848
R1221 Vg22.t15 Vg22.n43 664.848
R1222 Vg22.n4 Vg22.n3 208.887
R1223 Vg22.n4 Vg22.t16 227.982
R1224 Vg22.n40 Vg22.t18 664.848
R1225 Vg22.t18 Vg22.n39 664.848
R1226 Vg22.n19 Vg22.n0 208.887
R1227 Vg22.n19 Vg22.t19 227.982
R1228 Vg22.n2 Vg22.n1 208.887
R1229 Vg22.n2 Vg22.t20 227.982
R1230 Vg22.n17 Vg22.n18 208.887
R1231 Vg22.t21 Vg22.n18 227.982
R1232 Vg22.t22 Vg22.n33 664.848
R1233 Vg22.n38 Vg22.t22 664.848
R1234 Vg22.t23 Vg22.n14 227.982
R1235 Vg22.n27 Vg22.n14 208.887
R1236 Vg22.n36 Vg22.t24 664.848
R1237 Vg22.t24 Vg22.n35 664.848
R1238 Vg22.n22 Vg22.n21 208.887
R1239 Vg22.n45 Vg22.n29 609.164
R1240 Vg22.n9 Vg22.n4 208.887
R1241 Vg22.n41 Vg22.n32 609.164
R1242 Vg22.n25 Vg22.n19 208.887
R1243 Vg22.n10 Vg22.n2 208.887
R1244 Vg22.n18 Vg22.n26 208.887
R1245 Vg22.n37 Vg22.n15 609.164
R1246 Vg22.n16 Vg22.n14 208.887
R1247 Vg22.n28 Vg22.n7 208.704
R1248 Vg22.t9 Vg22.n59 598.711
R1249 Vg22.n55 Vg22.n54 595.696
R1250 Vg22.n52 Vg22.n50 594.106
R1251 Vg22.n12 Vg22.n11 361.173
R1252 Vg22.n51 Vg22.n48 361.173
R1253 Vg22.n52 Vg22.n51 336.416
R1254 Vg22.n53 Vg22.n49 320.106
R1255 Vg22.n59 Vg22.n11 320.106
R1256 Vg22.n57 Vg22.n56 320.106
R1257 Vg22.n58 Vg22.n57 320.106
R1258 Vg22.n49 Vg22.n48 320.106
R1259 Vg22.n11 Vg22.t8 292.873
R1260 Vg22.n57 Vg22.t4 292.873
R1261 Vg22.n51 Vg22.t0 292.873
R1262 Vg22.n49 Vg22.t2 292.873
R1263 Vg22.n34 Vg22.t25 284.125
R1264 Vg22.n46 Vg22.t13 227.982
R1265 Vg22.n31 Vg22.t17 227.982
R1266 Vg22.n46 Vg22.n20 208.887
R1267 Vg22.n47 Vg22.n46 208.887
R1268 Vg22.n42 Vg22.n31 208.887
R1269 Vg22.n31 Vg22.n30 208.887
R1270 Vg22.n36 Vg22.n34 131.65
R1271 Vg22.n35 Vg22.n34 130.256
R1272 Vg22 Vg22.t10 57.2705
R1273 Vg22.n58 Vg22.n48 41.0672
R1274 Vg22.n59 Vg22.n23 36.1123
R1275 Vg22.n56 Vg22.n53 36.1123
R1276 Vg22.n17 Vg22.n33 35.6108
R1277 Vg22.n40 Vg22.n0 35.6108
R1278 Vg22.n3 Vg22.n42 35.6108
R1279 Vg22.n16 Vg22.n36 35.1841
R1280 Vg22.n21 Vg22.n20 35.1841
R1281 Vg22.n42 Vg22.n41 34.3308
R1282 Vg22.n28 Vg22.n5 243.168
R1283 Vg22.n12 Vg22.n58 41.0672
R1284 Vg22.n5 Vg22.n20 36.4641
R1285 Vg22.n1 Vg22.n17 35.6108
R1286 Vg22.n1 Vg22.n0 35.6108
R1287 Vg22.n44 Vg22.n3 35.6108
R1288 Vg22.n21 Vg22.n45 34.7574
R1289 Vg22.n16 Vg22.n15 34.7574
R1290 Vg22.n8 Vg22.n47 33.101
R1291 Vg22.n9 Vg22.n30 33.101
R1292 Vg22.n39 Vg22.n25 33.101
R1293 Vg22.n26 Vg22.n38 33.101
R1294 Vg22.n43 Vg22.n9 33.101
R1295 Vg22.n10 Vg22.n26 33.1009
R1296 Vg22.n25 Vg22.n10 33.1009
R1297 Vg22.n47 Vg22.n24 32.7245
R1298 Vg22.n35 Vg22.n27 32.7245
R1299 Vg22.n8 Vg22.n7 32.6062
R1300 Vg22.n37 Vg22.n27 32.348
R1301 Vg22.n24 Vg22.n29 32.348
R1302 Vg22.n32 Vg22.n30 31.9715
R1303 Vg22.n60 Vg22.n7 20.8155
R1304 Vg22.n56 Vg22.n55 16.3102
R1305 Vg22.n53 Vg22.n52 16.3102
R1306 Vg22.n55 Vg22.n23 16.3102
R1307 Vg22.n60 Vg22 10.0248
R1308 Vg22 Vg22.t9 4.50349
R1309 Vg22 Vg22.n60 2.5113
R1310 Vg22.n50 Vg22.t3 1.84683
R1311 Vg22.n50 Vg22.t1 1.84683
R1312 Vg22.n54 Vg22.t7 1.84683
R1313 Vg22.n54 Vg22.t5 1.84683
R1314 Vg22.n15 Vg22.n33 1.2805
R1315 Vg22.n41 Vg22.n40 1.2805
R1316 Vg22.n45 Vg22.n44 1.2805
R1317 Vg22.n43 Vg22.n29 1.12991
R1318 Vg22.n39 Vg22.n32 1.12991
R1319 Vg22.n38 Vg22.n37 1.12991
R1320 m21_22_0.G m21_22_0.G.n15 598.711
R1321 m21_22_0.G.n2 m21_22_0.G.n3 320.106
R1322 m21_22_0.G.n2 m21_22_0.G.n1 320.106
R1323 m21_22_0.G.n2 m21_22_0.G.t6 292.873
R1324 m21_22_0.G.n11 m21_22_0.G.n10 595.696
R1325 m21_22_0.G.n8 m21_22_0.G.n6 594.106
R1326 m21_22_0.G.n1 m21_22_0.G.n0 361.173
R1327 m21_22_0.G.n7 m21_22_0.G.n4 361.173
R1328 m21_22_0.G.n8 m21_22_0.G.n7 336.416
R1329 m21_22_0.G.n9 m21_22_0.G.n5 320.106
R1330 m21_22_0.G.n15 m21_22_0.G.n0 320.106
R1331 m21_22_0.G.n13 m21_22_0.G.n12 320.106
R1332 m21_22_0.G.n14 m21_22_0.G.n13 320.106
R1333 m21_22_0.G.n5 m21_22_0.G.n4 320.106
R1334 m21_22_0.G.n0 m21_22_0.G.t8 292.873
R1335 m21_22_0.G.n13 m21_22_0.G.t4 292.873
R1336 m21_22_0.G.n7 m21_22_0.G.t0 292.873
R1337 m21_22_0.G.n5 m21_22_0.G.t2 292.873
R1338 m21_22_0.G.n14 m21_22_0.G.n4 41.0672
R1339 m21_22_0.G.n1 m21_22_0.G.n14 41.0672
R1340 m21_22_0.G.n15 m21_22_0.G.n3 36.1123
R1341 m21_22_0.G.n12 m21_22_0.G.n9 36.1123
R1342 m21_22_0.G.n12 m21_22_0.G.n11 16.3102
R1343 m21_22_0.G.n9 m21_22_0.G.n8 16.3102
R1344 m21_22_0.G.n11 m21_22_0.G.n3 16.3102
R1345 m21_22_0.G.n6 m21_22_0.G.t3 1.84683
R1346 m21_22_0.G.n6 m21_22_0.G.t1 1.84683
R1347 m21_22_0.G.n10 m21_22_0.G.t7 1.84683
R1348 m21_22_0.G.n10 m21_22_0.G.t5 1.84683
R1349 Vg27.n2 Vg27.n1 319.969
R1350 Vg27.n74 Vg27.n70 989.76
R1351 Vg27.n14 Vg27.n13 320.038
R1352 Vg27.n77 Vg27.n69 989.76
R1353 Vg27.n80 Vg27.n68 989.76
R1354 Vg27.n45 Vg27.n44 320.038
R1355 Vg27.n27 Vg27.n26 320.038
R1356 Vg27.n81 Vg27.n24 989.76
R1357 Vg27.n12 Vg27.n22 320.038
R1358 Vg27.n21 Vg27.n10 320.038
R1359 Vg27.n43 Vg27.n52 320.038
R1360 Vg27.n8 Vg27.n20 320.038
R1361 Vg27.n85 Vg27.n66 989.76
R1362 Vg27.n6 Vg27.n5 320.038
R1363 Vg27.n51 Vg27.n41 320.038
R1364 Vg27.n86 Vg27.n39 989.76
R1365 Vg27.n38 Vg27.n50 320.038
R1366 Vg27.n4 Vg27.n18 320.038
R1367 Vg27.n49 Vg27.n36 320.038
R1368 Vg27.n90 Vg27.n64 989.76
R1369 Vg27.n34 Vg27.n33 320.038
R1370 Vg27.n32 Vg27.n47 320.038
R1371 Vg27.n30 Vg27.n46 320.038
R1372 Vg27.n93 Vg27.n63 989.76
R1373 Vg27.t49 Vg27.n72 905.848
R1374 Vg27.n73 Vg27.t49 905.848
R1375 Vg27.n23 Vg27.n14 320.038
R1376 Vg27.t48 Vg27.n14 292.906
R1377 Vg27.t47 Vg27.n75 905.848
R1378 Vg27.n76 Vg27.t47 905.848
R1379 Vg27.n79 Vg27.t46 905.848
R1380 Vg27.t46 Vg27.n78 905.848
R1381 Vg27.n44 Vg27.n53 320.038
R1382 Vg27.n44 Vg27.t45 292.906
R1383 Vg27.n26 Vg27.t44 292.906
R1384 Vg27.n26 Vg27.n25 320.038
R1385 Vg27.n82 Vg27.t43 905.848
R1386 Vg27.t43 Vg27.n67 905.848
R1387 Vg27.t42 Vg27.n12 292.906
R1388 Vg27.n11 Vg27.n12 320.038
R1389 Vg27.n10 Vg27.t41 292.906
R1390 Vg27.n10 Vg27.n9 320.038
R1391 Vg27.t40 Vg27.n43 292.906
R1392 Vg27.n42 Vg27.n43 320.038
R1393 Vg27.t39 Vg27.n8 292.906
R1394 Vg27.n7 Vg27.n8 320.038
R1395 Vg27.n84 Vg27.t38 905.848
R1396 Vg27.t38 Vg27.n83 905.848
R1397 Vg27.n5 Vg27.n19 320.038
R1398 Vg27.n5 Vg27.t37 292.906
R1399 Vg27.n41 Vg27.t36 292.906
R1400 Vg27.n41 Vg27.n40 320.038
R1401 Vg27.n87 Vg27.t35 905.848
R1402 Vg27.t35 Vg27.n65 905.848
R1403 Vg27.t34 Vg27.n38 292.906
R1404 Vg27.n37 Vg27.n38 320.038
R1405 Vg27.t33 Vg27.n4 292.906
R1406 Vg27.n3 Vg27.n4 320.038
R1407 Vg27.n36 Vg27.t32 292.906
R1408 Vg27.n36 Vg27.n35 320.038
R1409 Vg27.t31 Vg27.n88 905.848
R1410 Vg27.n89 Vg27.t31 905.848
R1411 Vg27.n48 Vg27.n34 320.038
R1412 Vg27.t30 Vg27.n34 292.906
R1413 Vg27.t29 Vg27.n32 292.906
R1414 Vg27.n31 Vg27.n32 320.038
R1415 Vg27.t28 Vg27.n30 292.906
R1416 Vg27.n29 Vg27.n30 320.038
R1417 Vg27.n92 Vg27.t27 905.848
R1418 Vg27.t27 Vg27.n91 905.848
R1419 Vg27.n2 Vg27.t26 293.039
R1420 Vg27.n73 Vg27.n71 352.478
R1421 Vg27.n72 Vg27.n71 352.152
R1422 Vg27.n71 Vg27.t50 292.995
R1423 Vg27.n91 Vg27.n29 32.6199
R1424 Vg27.n35 Vg27.n3 32.6199
R1425 Vg27.n37 Vg27.n65 32.6199
R1426 Vg27.n83 Vg27.n7 32.6199
R1427 Vg27.n11 Vg27.n67 32.6199
R1428 Vg27.n9 Vg27.n11 32.6199
R1429 Vg27.n42 Vg27.n9 32.6199
R1430 Vg27.n7 Vg27.n42 32.6199
R1431 Vg27.n3 Vg27.n37 32.6199
R1432 Vg27.n89 Vg27.n35 32.6199
R1433 Vg27.n29 Vg27.n31 32.6199
R1434 Vg27.n31 Vg27.n33 32.4134
R1435 Vg27.n25 Vg27.n45 32.4134
R1436 Vg27.n92 Vg27.n46 32.2922
R1437 Vg27.n49 Vg27.n18 32.2922
R1438 Vg27.n50 Vg27.n87 32.2922
R1439 Vg27.n84 Vg27.n20 32.2922
R1440 Vg27.n22 Vg27.n82 32.2922
R1441 Vg27.n88 Vg27.n49 32.2922
R1442 Vg27.n47 Vg27.n46 32.2922
R1443 Vg27.n21 Vg27.n22 32.2922
R1444 Vg27.n52 Vg27.n21 32.2922
R1445 Vg27.n52 Vg27.n20 32.2921
R1446 Vg27.n50 Vg27.n18 32.2921
R1447 Vg27.n13 Vg27.n74 32.207
R1448 Vg27.n6 Vg27.n66 32.207
R1449 Vg27.n47 Vg27.n48 32.089
R1450 Vg27.n27 Vg27.n53 32.089
R1451 Vg27.n40 Vg27.n6 32.0005
R1452 Vg27.n76 Vg27.n13 32.0005
R1453 Vg27.n23 Vg27.n70 31.8858
R1454 Vg27.n19 Vg27.n85 31.8858
R1455 Vg27.n45 Vg27.n68 31.794
R1456 Vg27.n33 Vg27.n90 31.794
R1457 Vg27.n51 Vg27.n19 31.6826
R1458 Vg27.n75 Vg27.n23 31.6826
R1459 Vg27.n78 Vg27.n77 31.5876
R1460 Vg27.n25 Vg27.n24 31.5876
R1461 Vg27.n53 Vg27.n80 31.4795
R1462 Vg27.n48 Vg27.n64 31.4795
R1463 Vg27.n79 Vg27.n69 31.2763
R1464 Vg27.n81 Vg27.n27 31.2763
R1465 Vg27.n40 Vg27.n39 31.1747
R1466 Vg27.n63 Vg27.n1 30.9682
R1467 Vg27.n86 Vg27.n51 30.8699
R1468 Vg27.n2 Vg27.n93 350.851
R1469 Vg27.n28 Vg27.t3 26.2577
R1470 m13_14.D Vg27.t1 25.7242
R1471 Vg27.n97 Vg27.n96 25.3473
R1472 Vg27.n16 Vg27.n58 24.3889
R1473 Vg27.n15 Vg27.n60 24.2434
R1474 Vg27.n15 Vg27.n59 23.6341
R1475 Vg27.n16 Vg27.n57 23.6341
R1476 Vg27.n16 Vg27.n56 23.6341
R1477 Vg27.n17 Vg27.n55 23.6341
R1478 Vg27.n17 Vg27.n54 23.6341
R1479 Vg27.n97 Vg27.n95 23.5733
R1480 m27_0.G Vg27.n1 20.9633
R1481 Vg27.n0 Vg27.t18 11.3962
R1482 Vg27.n0 Vg27.n62 10.5964
R1483 Vg27.n0 Vg27.n61 9.76307
R1484 Vg27.n60 Vg27.t17 2.77
R1485 Vg27.n60 Vg27.t16 2.77
R1486 Vg27.n96 Vg27.t24 2.77
R1487 Vg27.n96 Vg27.t23 2.77
R1488 Vg27.n95 Vg27.t2 2.77
R1489 Vg27.n95 Vg27.t0 2.77
R1490 Vg27.n59 Vg27.t15 2.77
R1491 Vg27.n59 Vg27.t14 2.77
R1492 Vg27.n58 Vg27.t13 2.77
R1493 Vg27.n58 Vg27.t12 2.77
R1494 Vg27.n57 Vg27.t11 2.77
R1495 Vg27.n57 Vg27.t10 2.77
R1496 Vg27.n56 Vg27.t9 2.77
R1497 Vg27.n56 Vg27.t8 2.77
R1498 Vg27.n55 Vg27.t7 2.77
R1499 Vg27.n55 Vg27.t6 2.77
R1500 Vg27.n54 Vg27.t5 2.77
R1501 Vg27.n54 Vg27.t4 2.77
R1502 Vg27.n0 m27_0.G 1.86147
R1503 m13_14.D Vg27.n28 1.85542
R1504 Vg27.n94 Vg27.n0 1.75302
R1505 Vg27.n62 Vg27.t22 1.6535
R1506 Vg27.n62 Vg27.t21 1.6535
R1507 Vg27.n61 Vg27.t20 1.6535
R1508 Vg27.n61 Vg27.t19 1.6535
R1509 Vg27.n94 Vg27.t25 1.62149
R1510 m13_14.D Vg27.n97 1.59268
R1511 Vg27.n39 Vg27.n65 1.44566
R1512 Vg27.n87 Vg27.n86 1.42272
R1513 Vg27.n28 Vg27.n17 1.35895
R1514 Vg27.n16 Vg27.n15 1.24855
R1515 Vg27.n17 Vg27.n16 1.22706
R1516 Vg27.n28 Vg27.n94 1.20779
R1517 Vg27.n91 Vg27.n63 1.03276
R1518 Vg27.n90 Vg27.n89 1.03276
R1519 Vg27.n83 Vg27.n66 1.03276
R1520 Vg27.n24 Vg27.n67 1.03276
R1521 Vg27.n78 Vg27.n68 1.03276
R1522 Vg27.n77 Vg27.n76 1.03276
R1523 Vg27.n74 Vg27.n73 1.03276
R1524 Vg27.n93 Vg27.n92 1.01637
R1525 Vg27.n88 Vg27.n64 1.01637
R1526 Vg27.n85 Vg27.n84 1.01637
R1527 Vg27.n82 Vg27.n81 1.01637
R1528 Vg27.n80 Vg27.n79 1.01637
R1529 Vg27.n75 Vg27.n69 1.01637
R1530 Vg27.n72 Vg27.n70 1.01637
R1531 Vg11.n5 Vg11.t17 127.734
R1532 Vg11.n7 Vg11.t18 127.734
R1533 Vg11.n9 Vg11.t19 127.734
R1534 Vg11.n12 Vg11.t20 127.734
R1535 Vg11.n3 Vg11.t21 127.734
R1536 Vg11.n17 Vg11.t8 127.734
R1537 Vg11.n19 Vg11.t6 127.734
R1538 Vg11.n21 Vg11.t4 127.734
R1539 Vg11.n24 Vg11.t2 127.734
R1540 Vg11.n15 Vg11.t0 127.734
R1541 Vg11.n23 Vg11.n15 105.826
R1542 Vg11.n20 Vg11.n17 105.826
R1543 Vg11.n11 Vg11.n3 105.733
R1544 Vg11.n8 Vg11.n5 105.733
R1545 Vg11.n6 Vg11.n5 104.817
R1546 Vg11.n18 Vg11.n17 104.724
R1547 Vg11.n13 Vg11.n12 78.9354
R1548 Vg11.n9 Vg11.n4 78.9354
R1549 Vg11.n7 Vg11.n6 78.9354
R1550 Vg11.n25 Vg11.n24 78.8413
R1551 Vg11.n21 Vg11.n16 78.8413
R1552 Vg11.n19 Vg11.n18 78.8413
R1553 Vg11.n24 Vg11.n23 78.559
R1554 Vg11.n22 Vg11.n21 78.559
R1555 Vg11.n20 Vg11.n19 78.559
R1556 Vg11.n14 Vg11.n3 78.5121
R1557 Vg11.n26 Vg11.n15 78.5027
R1558 Vg11.n12 Vg11.n11 78.4648
R1559 Vg11.n10 Vg11.n9 78.4648
R1560 Vg11.n8 Vg11.n7 78.4648
R1561 Vg11.n47 Vg11.n39 57.5827
R1562 Vg11.n35 Vg11.n27 57.5529
R1563 Vg11.n44 Vg11.n41 56.4011
R1564 Vg11.n32 Vg11.n29 56.3714
R1565 Vg11.n30 Vg11.n29 55.4789
R1566 Vg11.n42 Vg11.n41 55.4491
R1567 Vg11.n29 Vg11.t26 49.5228
R1568 Vg11.n31 Vg11.t25 49.5228
R1569 Vg11.n33 Vg11.t24 49.5228
R1570 Vg11.n27 Vg11.t22 49.5228
R1571 Vg11.n41 Vg11.t31 49.5228
R1572 Vg11.n43 Vg11.t30 49.5228
R1573 Vg11.n45 Vg11.t29 49.5228
R1574 Vg11.n39 Vg11.t27 49.5228
R1575 Vg11.n36 Vg11.t23 48.8839
R1576 Vg11.n48 Vg11.t28 48.8839
R1577 Vg11.n38 Vg11.n37 30.9041
R1578 Vg11.n50 Vg11.n49 30.8821
R1579 Vg11.n35 Vg11.n34 28.7148
R1580 Vg11.n47 Vg11.n46 28.7148
R1581 Vg11.n37 Vg11.n28 27.8472
R1582 Vg11.n49 Vg11.n40 27.8472
R1583 Vg11.n37 Vg11.n36 27.0894
R1584 Vg11.n49 Vg11.n48 27.0577
R1585 Vg11.n48 Vg11.n47 27.026
R1586 Vg11.n36 Vg11.n35 26.9943
R1587 Vg11 Vg11.t9 26.8065
R1588 Vg11.n34 Vg11.n32 26.7456
R1589 Vg11.n46 Vg11.n44 26.7456
R1590 Vg11.n10 Vg11.n8 26.5043
R1591 Vg11.n22 Vg11.n20 26.5043
R1592 Vg11.n14 Vg11.n13 26.3037
R1593 Vg11.n26 Vg11.n25 26.2201
R1594 Vg11.n30 Vg11.n28 25.9921
R1595 Vg11.n42 Vg11.n40 25.9921
R1596 Vg11.n33 Vg11.n28 25.7771
R1597 Vg11.n31 Vg11.n30 25.7771
R1598 Vg11.n45 Vg11.n40 25.7474
R1599 Vg11.n43 Vg11.n42 25.7474
R1600 Vg11.n46 Vg11.n45 25.7176
R1601 Vg11.n44 Vg11.n43 25.7176
R1602 Vg11.n38 Vg11.n27 25.689
R1603 Vg11.n34 Vg11.n33 25.6878
R1604 Vg11.n32 Vg11.n31 25.6878
R1605 Vg11.n50 Vg11.n39 25.6814
R1606 Vg11.n6 Vg11.n4 25.2001
R1607 Vg11.n18 Vg11.n16 25.2001
R1608 Vg11.n11 Vg11.n10 24.9759
R1609 Vg11.n23 Vg11.n22 24.9759
R1610 Vg11.n13 Vg11.n4 23.8348
R1611 Vg11.n25 Vg11.n16 23.8348
R1612 Vg11.n51 Vg11.n1 23.5754
R1613 Vg11.n0 Vg11.n2 23.3568
R1614 Vg11.n55 Vg11.n54 10.9879
R1615 Vg11.n0 Vg11.n50 10.5767
R1616 Vg11.n0 Vg11.n38 10.5691
R1617 Vg11.n0 Vg11.n26 10.3781
R1618 Vg11.n0 Vg11.n14 10.3687
R1619 Vg11.n55 Vg11.n53 8.79046
R1620 Vg11.n56 Vg11.n52 8.79012
R1621 Vg11.n57 Vg11.t10 6.35402
R1622 Vg11 Vg11.n57 4.50202
R1623 Vg11.n57 Vg11 3.1462
R1624 Vg11.n2 Vg11.t3 2.77
R1625 Vg11.n2 Vg11.t1 2.77
R1626 Vg11.n1 Vg11.t7 2.77
R1627 Vg11.n1 Vg11.t5 2.77
R1628 Vg11.n56 Vg11.n55 2.20723
R1629 Vg11 Vg11.n56 2.20242
R1630 Vg11.n51 Vg11.n0 1.94493
R1631 Vg11 Vg11.n51 1.58514
R1632 Vg11.n52 Vg11.t12 1.15644
R1633 Vg11.n52 Vg11.t11 1.15644
R1634 Vg11.n53 Vg11.t14 1.15644
R1635 Vg11.n53 Vg11.t13 1.15644
R1636 Vg11.n54 Vg11.t16 1.15644
R1637 Vg11.n54 Vg11.t15 1.15644
R1638 Vg5.n7 Vg5.t7 78.1706
R1639 Vg5.n9 Vg5.t8 78.1706
R1640 Vg5.n6 Vg5.t9 78.1706
R1641 Vg5.n8 Vg5.n7 71.5898
R1642 Vg5.n8 Vg5.n6 70.4046
R1643 Vg5.n10 Vg5.n7 69.9953
R1644 Vg5.t0 Vg5.n18 49.5211
R1645 Vg5.n18 Vg5.t3 48.3967
R1646 Vg5.t3 Vg5.n17 48.0394
R1647 Vg5.n4 Vg5.n1 44.6492
R1648 Vg5.n2 Vg5.n1 44.1261
R1649 Vg5.n10 Vg5.n9 41.3548
R1650 Vg5.n11 Vg5.n6 41.3247
R1651 Vg5.n9 Vg5.n8 41.206
R1652 Vg5.n2 Vg5.t10 38.8067
R1653 Vg5.t13 Vg5.n15 33.9888
R1654 Vg5.n15 Vg5.t15 30.6204
R1655 Vg5.t15 Vg5.n14 29.6765
R1656 Vg5.n11 Vg5.n10 27.6398
R1657 Vg5.n19 Vg5.n17 26.7657
R1658 Vg5.n5 Vg5.n4 26.7081
R1659 Vg5 Vg5.t4 26.5534
R1660 Vg5.n16 Vg5.n14 25.9214
R1661 Vg5.n1 Vg5.t12 24.9546
R1662 Vg5.n3 Vg5.t11 24.9546
R1663 Vg5 Vg5.n12 24.2116
R1664 Vg5.n19 Vg5.t0 22.3675
R1665 Vg5.t2 Vg5.n17 22.3675
R1666 Vg5.n18 Vg5.t2 22.3303
R1667 Vg5.n0 Vg5.n16 22.0485
R1668 Vg5.n0 Vg5.n19 15.8695
R1669 Vg5 Vg5.n11 12.795
R1670 Vg5.n3 Vg5.n2 12.5364
R1671 Vg5.n4 Vg5.n3 12.5364
R1672 Vg5.n5 Vg5.t10 12.4812
R1673 Vg5 Vg5.n5 10.9971
R1674 Vg5.n16 Vg5.t13 6.8776
R1675 Vg5.t14 Vg5.n14 6.8776
R1676 Vg5.n15 Vg5.t14 6.83559
R1677 Vg5.n12 Vg5.t6 4.96446
R1678 Vg5.n12 Vg5.t5 4.96446
R1679 Vg5.n0 Vg5.n13 4.5005
R1680 Vg5.n13 Vg5 3.00049
R1681 Vg5 Vg5.t1 2.28042
R1682 Vg5.n13 Vg5 1.80364
R1683 Vg5.t1 Vg5.n0 1.41017
R1684 Vd8.n3 Vd8.n2 2.50181
R1685 Vd8.n11 Vd8.n4 2.50181
R1686 Vd8.n16 Vd8.n8 4764.41
R1687 Vd8.n11 Vd8.n8 4764.41
R1688 Vd8.n19 Vd8.n2 4764.41
R1689 Vd8.n20 Vd8.n19 4764.41
R1690 Vd8.n18 Vd8.n8 3372.83
R1691 Vd8.n19 Vd8.n18 3372.83
R1692 Vd8.n13 Vd8.n10 650.542
R1693 Vd8.n10 Vd8.n9 650.542
R1694 Vd8.n17 Vd8.t0 625.761
R1695 Vd8.n17 Vd8.t13 625.761
R1696 Vd8.n15 Vd8.n14 171.149
R1697 Vd8.n12 Vd8.n7 163.393
R1698 Vd8.n14 Vd8.n6 155.756
R1699 Vd8.n21 Vd8.n7 147.238
R1700 Vd8.n15 Vd8.n13 94.0223
R1701 Vd8.n13 Vd8.n12 94.0223
R1702 Vd8.n9 Vd8.n6 78.8742
R1703 Vd8.n21 m09_10_0.S 64.2185
R1704 Vd8.n1 Vd8.t12 22.1199
R1705 Vd8.n1 Vd8.n5 21.3777
R1706 Vd8.n0 Vd8.n27 15.3676
R1707 Vd8.n0 Vd8.n28 15.3665
R1708 Vd8.n1 Vd8.n23 15.3659
R1709 Vd8.n0 Vd8.n25 15.3653
R1710 Vd8.n0 Vd8.n26 15.3513
R1711 Vd8.n0 Vd8.n29 15.3502
R1712 Vd8.n1 Vd8.n22 15.3496
R1713 Vd8.n0 Vd8.n24 15.349
R1714 Vd8.n9 m09_10_0.S 14.6563
R1715 Vd8.n21 Vd8.t14 10.2469
R1716 Vd8.n6 Vd8.t1 10.2469
R1717 Vd8.n1 Vd8.n21 6.36463
R1718 Vd8.n1 Vd8.n6 6.34832
R1719 Vd8.n18 Vd8.n17 3.77601
R1720 Vd8.n18 Vd8.n10 3.77601
R1721 Vd8.n14 Vd8.n3 548.635
R1722 Vd8.n4 Vd8.n7 548.635
R1723 Vd8.n20 Vd8.t13 2.68184
R1724 Vd8.t0 Vd8.n16 2.68184
R1725 Vd8.t0 Vd8.n3 0.180527
R1726 Vd8.n2 Vd8.n6 2.68166
R1727 Vd8.n4 Vd8.t13 0.180527
R1728 Vd8.n12 Vd8.n11 2.68166
R1729 Vd8.n16 Vd8.n15 2.68166
R1730 Vd8.n21 Vd8.n20 2.68166
R1731 Vd8.n5 Vd8.t11 2.09861
R1732 Vd8.n5 Vd8.t10 2.09861
R1733 Vd8.n1 Vd8.n0 1.87461
R1734 Vd8.n29 Vd8.t9 1.2469
R1735 Vd8.n29 Vd8.t8 1.2469
R1736 Vd8.n22 Vd8.t3 1.2469
R1737 Vd8.n22 Vd8.t2 1.2469
R1738 Vd8.n23 Vd8.t16 1.2469
R1739 Vd8.n23 Vd8.t15 1.2469
R1740 Vd8.n24 Vd8.t5 1.2469
R1741 Vd8.n24 Vd8.t4 1.2469
R1742 Vd8.n25 Vd8.t18 1.2469
R1743 Vd8.n25 Vd8.t17 1.2469
R1744 Vd8.n26 Vd8.t7 1.2469
R1745 Vd8.n26 Vd8.t6 1.2469
R1746 Vd8.n27 Vd8.t20 1.2469
R1747 Vd8.n27 Vd8.t19 1.2469
R1748 Vd8.n28 Vd8.t22 1.2469
R1749 Vd8.n28 Vd8.t21 1.2469
C0 a_23419_13228# VDD 2.05436f
C1 m21_22_0.G Vg5 0.02277f
C2 VDD Vg1 0.91787f
C3 Vs29 Vn 9.92975f
C4 Vg11 Vd29 10.4469f
C5 Vd9 VDD 0.64914f
C6 Vg5 Vd29 0.25303f
C7 Vg11 Vg1 9.42797f
C8 a_23419_13228# Vg5 5.58455f
C9 Vg5 Vg1 2.03511f
C10 Vs29 Vd30 1.33416f
C11 Vn Vd30 10.4011f
C12 VDD Vout 76.6391f
C13 Vd9 Vg5 0.16581f
C14 Vd24 Vg1 0.0106f
C15 Vd10 Vd29 0.2311f
C16 Vout Vg11 14.6012f
C17 Vg5 Vout 8.86844f
C18 a_27266_764# Vg1 3.06803f
C19 Vd10 Vg1 10.6308f
C20 Vd9 Vd10 0.10617f
C21 Vout Vd24 8.73014f
C22 m21_22_0.G Vg22 7.55308f
C23 VDD Vg11 32.2079f
C24 Vg5 VDD 40.7574f
C25 Vd10 Vout 2.74436f
C26 Vg22 Vd29 0.04172f
C27 Vg22 Vg1 0.20657f
C28 Vg5 Vg11 0.31764f
C29 VDD Vd24 1.43524f
C30 VgR2 Vref 0.44878f
C31 Vg22 Vd9 0.03251f
C32 Vp Vd29 10.8923f
C33 M03_04.sky130_fd_pr__nfet_g5v0d10v5_Y3KDPX_0.D Vg1 1.94488f
C34 Vd10 VDD 0.15019f
C35 Vg5 Vd24 0.35009f
C36 Vg22 Vout 14.9903f
C37 Vs29 Vd29 1.35488f
C38 Vn Vd29 0.49302f
C39 Vd9 Vp 18.2351f
C40 Vd10 Vg11 1.0502f
C41 Vs29 Vg1 2.19683f
C42 Vd9 Vs29 0.30359f
C43 Vd9 Vn 0.15849f
C44 Vg22 VDD 16.6797f
C45 Vd30 Vd29 0.63978f
C46 Vn Vout 0.036f
C47 Vd10 a_27266_764# 0.01875f
C48 Vg22 Vg11 0.04504f
C49 a_26297_13170# VDD 3.11738f
C50 Vg22 Vg5 0.47729f
C51 Vp VDD 0.03085f
C52 M03_04.sky130_fd_pr__nfet_g5v0d10v5_Y3KDPX_0.D Vg5 0.13145f
C53 Vout Vd30 2.41002f
C54 Vn VDD 0.03218f
C55 Vg22 Vd24 0.13679f
C56 a_26297_13170# Vg5 8.72513f
C57 Vp Vg5 0.07843f
C58 Vs29 Vg5 0.02921f
C59 VDD Vd30 7.7221f
C60 VgR2 Vg1 0.39363f
C61 Vg11 Vd30 11.109f
C62 Vg5 Vd30 0.01837f
C63 Vs29 a_27266_764# 0.22218f
C64 Vd9 VgR2 0.05889f
C65 Vd10 Vn 18.2348f
C66 Vd10 Vd30 0.60108f
C67 Vd9 Vd29 0.11377f
C68 m21_22_0.G Vout 3.45718f
C69 Vd9 Vg1 12.2623f
C70 VgR2 VDD 6.86668f
C71 Vout Vd29 10.5066f
C72 Vout Vg1 15.5047f
C73 m01_02.sky130_fd_pr__nfet_g5v0d10v5_Y3KDPX_0.D Vg1 2.04512f
C74 Vs29 M03_04.sky130_fd_pr__nfet_g5v0d10v5_Y3KDPX_0.D 0.01075f
C75 m21_22_0.G VDD 11.9025f
C76 Vs29 Vp 9.9276f
C77 Vp Vn 0.65616f
C78 Vd9 Vout 6.73022f
C79 Vg5 VgR2 0.55239f
C80 VDD Vd29 9.84027f
C81 Vout GND 93.92973f
C82 Vn GND 6.42342f
C83 Vp GND 7.28048f
C84 VDD GND 0.42241p
C85 a_27266_764# GND 1.58112f
C86 M03_04.sky130_fd_pr__nfet_g5v0d10v5_Y3KDPX_0.D GND 0.93317f
C87 m01_02.sky130_fd_pr__nfet_g5v0d10v5_Y3KDPX_0.D GND 0.97959f
C88 Vs29 GND 12.75977f
C89 Vd24 GND 33.98119f
C90 Vd10 GND 43.87075f
C91 Vd9 GND 23.79494f
C92 Vg22 GND 17.42663f
C93 m21_22_0.G GND 12.50321f
C94 Vd29 GND 14.25623f
C95 Vd30 GND 12.74585f
C96 Vg11 GND 6.9305f
C97 a_26297_13170# GND 6.43819f
C98 a_23419_13228# GND 5.7507f
C99 Vd8.n0 GND 2.52866f
C100 Vd8.n1 GND 2.31223f
C101 Vd8.n2 GND 0.25158f
C102 Vd8.n3 GND 0.04552f
C103 Vd8.t0 GND 11.7845f
C104 Vd8.t13 GND 11.7845f
C105 Vd8.n4 GND 0.04552f
C106 Vd8.t12 GND 0.84999f
C107 Vd8.t10 GND 0.66326f
C108 Vd8.t11 GND 0.66326f
C109 Vd8.n5 GND 0.17381f
C110 Vd8.t1 GND 1.00675f
C111 Vd8.n6 GND 2.09383f
C112 Vd8.n7 GND 8.58733f
C113 Vd8.t14 GND 1.01743f
C114 m09_10_0.S GND 0.65159f
C115 Vd8.n8 GND 0.25067f
C116 Vd8.n9 GND 0.69706f
C117 Vd8.n10 GND 0.07737f
C118 Vd8.n11 GND 0.25158f
C119 Vd8.n12 GND 1.49086f
C120 Vd8.n13 GND 1.09204f
C121 Vd8.n14 GND 8.37851f
C122 Vd8.n15 GND 1.49171f
C123 Vd8.n16 GND 0.25158f
C124 Vd8.n17 GND 11.7465f
C125 Vd8.n18 GND 0.13106f
C126 Vd8.n19 GND 0.25067f
C127 Vd8.n20 GND 0.25158f
C128 Vd8.n21 GND 1.96824f
C129 Vd8.t2 GND 0.78316f
C130 Vd8.t3 GND 0.78316f
C131 Vd8.n22 GND 0.33438f
C132 Vd8.t15 GND 0.79384f
C133 Vd8.t16 GND 0.79384f
C134 Vd8.n23 GND 0.3347f
C135 Vd8.t4 GND 0.78316f
C136 Vd8.t5 GND 0.78316f
C137 Vd8.n24 GND 0.33437f
C138 Vd8.t17 GND 0.79384f
C139 Vd8.t18 GND 0.79384f
C140 Vd8.n25 GND 0.33469f
C141 Vd8.t6 GND 0.78316f
C142 Vd8.t7 GND 0.78316f
C143 Vd8.n26 GND 0.33441f
C144 Vd8.t19 GND 0.79384f
C145 Vd8.t20 GND 0.79384f
C146 Vd8.n27 GND 0.33474f
C147 Vd8.t21 GND 0.79384f
C148 Vd8.t22 GND 0.79384f
C149 Vd8.n28 GND 0.33472f
C150 Vd8.t8 GND 0.78316f
C151 Vd8.t9 GND 0.78316f
C152 Vd8.n29 GND 0.33439f
C153 Vg5.n0 GND 0.16357f
C154 Vg5.n1 GND 4.08707f
C155 Vg5.n2 GND 4.43553f
C156 Vg5.n3 GND 0.13047f
C157 Vg5.n4 GND 3.53082f
C158 Vg5.n5 GND 2.76979f
C159 Vg5.n6 GND 0.60727f
C160 Vg5.n7 GND 1.19298f
C161 Vg5.n8 GND 3.01668f
C162 Vg5.n9 GND 0.02983f
C163 Vg5.n10 GND 2.22314f
C164 Vg5.n11 GND 1.40638f
C165 Vg5.t5 GND 0.01841f
C166 Vg5.t6 GND 0.01841f
C167 Vg5.n12 GND 0.05392f
C168 Vg5.t4 GND 0.06501f
C169 Vg5.n13 GND 0.54831f
C170 Vg5.n14 GND 1.81845f
C171 Vg5.n15 GND 2.09928f
C172 Vg5.n16 GND 1.48213f
C173 Vg5.n17 GND 1.05797f
C174 Vg5.n18 GND 1.38018f
C175 Vg5.n19 GND 0.72789f
C176 Vg5.t1 GND 1.35833f
C177 Vg11.n0 GND 0.93253f
C178 Vg11.t9 GND 0.67814f
C179 Vg11.t5 GND 0.42245f
C180 Vg11.t7 GND 0.42245f
C181 Vg11.n1 GND 0.20221f
C182 Vg11.t1 GND 0.42245f
C183 Vg11.t3 GND 0.42245f
C184 Vg11.n2 GND 0.19865f
C185 Vg11.n3 GND 0.18586f
C186 Vg11.n4 GND 0.63279f
C187 Vg11.n5 GND 0.34557f
C188 Vg11.n6 GND 1.10927f
C189 Vg11.n7 GND 0.02702f
C190 Vg11.n8 GND 1.10089f
C191 Vg11.n9 GND 0.02702f
C192 Vg11.n10 GND 0.6322f
C193 Vg11.n11 GND 1.09884f
C194 Vg11.n12 GND 0.02702f
C195 Vg11.n13 GND 0.63354f
C196 Vg11.n14 GND 0.64665f
C197 Vg11.n15 GND 0.18618f
C198 Vg11.n16 GND 0.63351f
C199 Vg11.n17 GND 0.34557f
C200 Vg11.n18 GND 1.11039f
C201 Vg11.n19 GND 0.02702f
C202 Vg11.n20 GND 1.09978f
C203 Vg11.n21 GND 0.02702f
C204 Vg11.n22 GND 0.63148f
C205 Vg11.n23 GND 1.09772f
C206 Vg11.n24 GND 0.02702f
C207 Vg11.n25 GND 0.63417f
C208 Vg11.n26 GND 0.64679f
C209 Vg11.n27 GND 1.08656f
C210 Vg11.n28 GND 1.85139f
C211 Vg11.n29 GND 2.06406f
C212 Vg11.n30 GND 2.71031f
C213 Vg11.n31 GND 0.06943f
C214 Vg11.n32 GND 2.69502f
C215 Vg11.n33 GND 0.06943f
C216 Vg11.n34 GND 1.85237f
C217 Vg11.n35 GND 2.6049f
C218 Vg11.n36 GND 0.0675f
C219 Vg11.n37 GND 1.77935f
C220 Vg11.n38 GND 1.86444f
C221 Vg11.n39 GND 1.1031f
C222 Vg11.n40 GND 1.85346f
C223 Vg11.n41 GND 2.06405f
C224 Vg11.n42 GND 2.71281f
C225 Vg11.n43 GND 0.06944f
C226 Vg11.n44 GND 2.69252f
C227 Vg11.n45 GND 0.06944f
C228 Vg11.n46 GND 1.85029f
C229 Vg11.n47 GND 2.61593f
C230 Vg11.n48 GND 0.0675f
C231 Vg11.n49 GND 1.78133f
C232 Vg11.n50 GND 1.86498f
C233 Vg11.n51 GND 0.44472f
C234 Vg11.t10 GND 0.42331f
C235 Vg11.t11 GND 0.10866f
C236 Vg11.t12 GND 0.10866f
C237 Vg11.n52 GND 0.46946f
C238 Vg11.t13 GND 0.10866f
C239 Vg11.t14 GND 0.10866f
C240 Vg11.n53 GND 0.46947f
C241 Vg11.t15 GND 0.10866f
C242 Vg11.t16 GND 2.45549f
C243 Vg11.n54 GND 0.55451f
C244 Vg11.n55 GND 0.82483f
C245 Vg11.n56 GND 0.48481f
C246 Vg11.n57 GND 1.81232f
C247 Vg27.n0 GND 1.75502f
C248 Vg27.n1 GND 0.22216f
C249 Vg27.n2 GND 0.01933f
C250 Vg27.n3 GND 0.22189f
C251 Vg27.n6 GND 0.22169f
C252 Vg27.n7 GND 0.22189f
C253 Vg27.n9 GND 0.22179f
C254 Vg27.n11 GND 0.22194f
C255 Vg27.n13 GND 0.22169f
C256 Vg27.n15 GND 0.5043f
C257 Vg27.n16 GND 0.78068f
C258 Vg27.n17 GND 0.52355f
C259 Vg27.n18 GND 0.22205f
C260 Vg27.n19 GND 0.22185f
C261 Vg27.n20 GND 0.22205f
C262 Vg27.n21 GND 0.22195f
C263 Vg27.n22 GND 0.2221f
C264 Vg27.n23 GND 0.22185f
C265 m27_0.G GND 0.84885f
C266 Vg27.n24 GND 0.10606f
C267 Vg27.n25 GND 0.22159f
C268 Vg27.n27 GND 0.22175f
C269 Vg27.n28 GND 1.78121f
C270 Vg27.n29 GND 0.22179f
C271 Vg27.n31 GND 0.22174f
C272 Vg27.n33 GND 0.22159f
C273 Vg27.n35 GND 0.22184f
C274 Vg27.n37 GND 0.22169f
C275 Vg27.n39 GND 0.1061f
C276 Vg27.n40 GND 0.22135f
C277 Vg27.n42 GND 0.22154f
C278 Vg27.n45 GND 0.22159f
C279 Vg27.n46 GND 0.22195f
C280 Vg27.n47 GND 0.2219f
C281 Vg27.n48 GND 0.22175f
C282 Vg27.n49 GND 0.222f
C283 Vg27.n50 GND 0.22185f
C284 Vg27.n51 GND 0.2215f
C285 Vg27.n52 GND 0.2217f
C286 Vg27.n53 GND 0.22175f
C287 m13_14.D GND 0.98433f
C288 Vg27.t1 GND 0.53782f
C289 Vg27.t3 GND 0.55105f
C290 Vg27.t4 GND 0.38691f
C291 Vg27.t5 GND 0.38691f
C292 Vg27.n54 GND 0.12327f
C293 Vg27.t6 GND 0.38691f
C294 Vg27.t7 GND 0.38691f
C295 Vg27.n55 GND 0.12327f
C296 Vg27.t8 GND 0.38691f
C297 Vg27.t9 GND 0.38691f
C298 Vg27.n56 GND 0.12327f
C299 Vg27.t10 GND 0.38691f
C300 Vg27.t11 GND 0.38691f
C301 Vg27.n57 GND 0.12327f
C302 Vg27.t12 GND 0.38691f
C303 Vg27.t13 GND 0.38691f
C304 Vg27.n58 GND 0.1302f
C305 Vg27.t14 GND 0.38691f
C306 Vg27.t15 GND 0.38691f
C307 Vg27.n59 GND 0.12327f
C308 Vg27.t16 GND 0.38691f
C309 Vg27.t17 GND 0.38699f
C310 Vg27.n60 GND 0.1295f
C311 Vg27.t18 GND 0.50662f
C312 Vg27.t19 GND 0.32613f
C313 Vg27.t20 GND 0.32613f
C314 Vg27.n61 GND 0.16533f
C315 Vg27.t21 GND 0.32613f
C316 Vg27.t22 GND 0.32613f
C317 Vg27.n62 GND 0.18129f
C318 Vg27.n63 GND 0.10601f
C319 Vg27.n64 GND 0.10623f
C320 Vg27.n65 GND 0.11598f
C321 Vg27.n66 GND 0.10615f
C322 Vg27.n67 GND 0.11588f
C323 Vg27.n68 GND 0.10615f
C324 Vg27.n69 GND 0.10623f
C325 Vg27.n70 GND 0.10623f
C326 Vg27.n71 GND 0.04f
C327 Vg27.n72 GND 0.31468f
C328 Vg27.n73 GND 0.31405f
C329 Vg27.n74 GND 0.10615f
C330 Vg27.n75 GND 0.11582f
C331 Vg27.n76 GND 0.11574f
C332 Vg27.n77 GND 0.10615f
C333 Vg27.n78 GND 0.11564f
C334 Vg27.n79 GND 0.11572f
C335 Vg27.n80 GND 0.10623f
C336 Vg27.n81 GND 0.10613f
C337 Vg27.n82 GND 0.11597f
C338 Vg27.n83 GND 0.11588f
C339 Vg27.n84 GND 0.11597f
C340 Vg27.n85 GND 0.10623f
C341 Vg27.n86 GND 0.10618f
C342 Vg27.n87 GND 0.11607f
C343 Vg27.n88 GND 0.11592f
C344 Vg27.n89 GND 0.11583f
C345 Vg27.n90 GND 0.10615f
C346 Vg27.n91 GND 0.11588f
C347 Vg27.n92 GND 0.11597f
C348 Vg27.n93 GND 0.30793f
C349 Vg27.n94 GND 1.51915f
C350 Vg27.t0 GND 0.39258f
C351 Vg27.t2 GND 0.39258f
C352 Vg27.n95 GND 0.1227f
C353 Vg27.t23 GND 0.39258f
C354 Vg27.t24 GND 0.39258f
C355 Vg27.n96 GND 0.14004f
C356 Vg27.n97 GND 0.5039f
C357 m21_22_0.G.n0 GND 0.06563f
C358 m21_22_0.G.n1 GND 1.09402f
C359 m21_22_0.G.n3 GND 0.57895f
C360 m21_22_0.G.n4 GND 1.09261f
C361 m21_22_0.G.t1 GND 0.57331f
C362 m21_22_0.G.t3 GND 0.57331f
C363 m21_22_0.G.n6 GND 1.26012f
C364 m21_22_0.G.n7 GND 0.0932f
C365 m21_22_0.G.n8 GND 0.69757f
C366 m21_22_0.G.n9 GND 0.57869f
C367 m21_22_0.G.t5 GND 0.57331f
C368 m21_22_0.G.t7 GND 0.57331f
C369 m21_22_0.G.n10 GND 1.26044f
C370 m21_22_0.G.n11 GND 0.15222f
C371 m21_22_0.G.n12 GND 0.57869f
C372 m21_22_0.G.n14 GND 0.58205f
C373 m21_22_0.G.n15 GND 0.70146f
C374 Vg22.n0 GND 0.50829f
C375 Vg22.n1 GND 0.50857f
C376 Vg22.n3 GND 0.50912f
C377 Vg22.n5 GND 0.89497f
C378 Vg22.n7 GND 0.92107f
C379 Vg22.n8 GND 0.46974f
C380 Vg22.n9 GND 0.51327f
C381 Vg22.n10 GND 0.51269f
C382 Vg22.n11 GND 0.07988f
C383 Vg22.n12 GND 1.33154f
C384 Vg22.n15 GND 0.26059f
C385 Vg22.n16 GND 0.50802f
C386 Vg22.n17 GND 0.50885f
C387 Vg22.n20 GND 0.50829f
C388 Vg22.n21 GND 0.50802f
C389 Vg22.n23 GND 0.70465f
C390 Vg22.n24 GND 0.51212f
C391 Vg22.n25 GND 0.51241f
C392 Vg22.n26 GND 0.51298f
C393 Vg22.n27 GND 0.51212f
C394 Vg22.n28 GND 0.07057f
C395 Vg22.n29 GND 0.26256f
C396 Vg22.n30 GND 0.51184f
C397 Vg22.n32 GND 0.26256f
C398 Vg22.n33 GND 0.24881f
C399 Vg22.n34 GND 0.12271f
C400 Vg22.n35 GND 0.96602f
C401 Vg22.n36 GND 0.95629f
C402 Vg22.n37 GND 0.26256f
C403 Vg22.n38 GND 0.25099f
C404 Vg22.n39 GND 0.25099f
C405 Vg22.n40 GND 0.24881f
C406 Vg22.n41 GND 0.26059f
C407 Vg22.n42 GND 0.50774f
C408 Vg22.n43 GND 0.25042f
C409 Vg22.n44 GND 0.24825f
C410 Vg22.n45 GND 0.26059f
C411 Vg22.n47 GND 0.51241f
C412 Vg22.n48 GND 1.32982f
C413 Vg22.t1 GND 0.69778f
C414 Vg22.t3 GND 0.69778f
C415 Vg22.n50 GND 1.5337f
C416 Vg22.n51 GND 0.11343f
C417 Vg22.n52 GND 0.84902f
C418 Vg22.n53 GND 0.70433f
C419 Vg22.t5 GND 0.69778f
C420 Vg22.t7 GND 0.69778f
C421 Vg22.n54 GND 1.53409f
C422 Vg22.n55 GND 0.18527f
C423 Vg22.n56 GND 0.70433f
C424 Vg22.n58 GND 0.70842f
C425 Vg22.n59 GND 0.85375f
C426 Vg22.t9 GND 2.29603f
C427 Vg22.n60 GND 12.6645f
C428 Vg22.t10 GND 0.07674f
C429 Vd24.n0 GND 0.19929f
C430 Vd24.n1 GND 0.01221f
C431 Vd24.n2 GND 0.01223f
C432 Vd24.n3 GND 0.19879f
C433 Vd24.n4 GND 0.26108f
C434 Vd24.n6 GND 0.21217f
C435 Vd24.n8 GND 0.36416f
C436 Vd24.n10 GND 0.21521f
C437 Vd24.n11 GND 0.46734f
C438 Vd24.n12 GND 0.05593f
C439 Vd24.n13 GND 0.16638f
C440 Vd24.n14 GND 0.36585f
C441 Vd24.n15 GND 0.06044f
C442 Vd24.n16 GND 0.21759f
C443 Vd24.n17 GND 0.2168f
C444 Vd24.n18 GND 0.27864f
C445 Vd24.t3 GND 0.2282f
C446 Vd24.t5 GND 0.2282f
C447 Vd24.n19 GND 0.1237f
C448 Vd24.n20 GND 0.27313f
C449 Vd24.t7 GND 0.2282f
C450 Vd24.t9 GND 0.22826f
C451 Vd24.n21 GND 0.1237f
C452 Vd24.n22 GND 0.27408f
C453 Vd24.n23 GND 0.23347f
C454 Vd24.n24 GND 0.07175f
C455 Vd24.n25 GND 0.22844f
C456 Vd24.n26 GND 0.06657f
C457 Vd24.t1 GND 0.37661f
C458 Vd24.n27 GND 0.21436f
C459 Vd24.n28 GND 0.16565f
C460 Vd24.n29 GND 0.11915f
C461 Vd24.n30 GND 0.51366f
C462 Vd24.n31 GND 0.51745f
C463 Vd24.n32 GND 0.16647f
C464 Vd24.n33 GND 0.16556f
C465 Vd24.n34 GND 0.50343f
C466 Vd24.n35 GND 0.20065f
C467 Vg28.n0 GND 0.12966f
C468 Vg28.n1 GND 0.01447f
C469 Vg28.n2 GND 2.59432f
C470 Vg28.n3 GND 0.12898f
C471 Vg28.n5 GND 0.12885f
C472 Vg28.n8 GND 0.12885f
C473 Vg28.n9 GND 0.12885f
C474 Vg28.n12 GND 0.12885f
C475 Vg28.n13 GND 0.12885f
C476 Vg28.n16 GND 0.12885f
C477 Vg28.n17 GND 0.12885f
C478 Vg28.n19 GND 0.12968f
C479 Vg28.n20 GND 0.12968f
C480 Vg28.n21 GND 0.12968f
C481 Vg28.n22 GND 0.12968f
C482 Vg28.n23 GND 0.12968f
C483 Vg28.n24 GND 0.12968f
C484 Vg28.n25 GND 0.12968f
C485 Vg28.n26 GND 0.1298f
C486 m28_0.G GND 1.49898f
C487 Vg28.n27 GND 0.24253f
C488 Vg28.n29 GND 0.12889f
C489 Vg28.n30 GND 0.12881f
C490 Vg28.n34 GND 0.12877f
C491 Vg28.n35 GND 0.24104f
C492 Vg28.n37 GND 0.12968f
C493 Vg28.n38 GND 0.12959f
C494 Vg28.n39 GND 0.12972f
C495 Vg28.n40 GND 0.12963f
C496 Vg28.n41 GND 0.02679f
C497 Vg28.n42 GND 0.24298f
C498 M17_18.D GND 0.07036f
C499 Vg28.t20 GND 0.2034f
C500 Vg28.t9 GND 0.47023f
C501 Vg28.t2 GND 0.31992f
C502 Vg28.t3 GND 0.31992f
C503 Vg28.n43 GND 0.14336f
C504 Vg28.t11 GND 0.31999f
C505 Vg28.t0 GND 0.31992f
C506 Vg28.n44 GND 0.15693f
C507 Vg28.n45 GND 0.3499f
C508 Vg28.n46 GND 0.45509f
C509 Vg28.n47 GND 1.00607f
C510 Vg28.t7 GND 0.49782f
C511 Vg28.t14 GND 0.39459f
C512 Vg28.t13 GND 0.3807f
C513 Vg28.n48 GND 0.11599f
C514 Vg28.t18 GND 0.3807f
C515 Vg28.t17 GND 0.3807f
C516 Vg28.n49 GND 0.1072f
C517 Vg28.n50 GND 0.41154f
C518 Vg28.t19 GND 0.3807f
C519 Vg28.t16 GND 0.3807f
C520 Vg28.n51 GND 0.1072f
C521 Vg28.n52 GND 0.2133f
C522 Vg28.t12 GND 0.3807f
C523 Vg28.t10 GND 0.3807f
C524 Vg28.n53 GND 0.1072f
C525 Vg28.n54 GND 0.21335f
C526 Vg28.t8 GND 0.3807f
C527 Vg28.t15 GND 0.3807f
C528 Vg28.n55 GND 0.1072f
C529 Vg28.n56 GND 0.21358f
C530 Vg28.t6 GND 0.3807f
C531 Vg28.t1 GND 0.3807f
C532 Vg28.n57 GND 0.1072f
C533 Vg28.n58 GND 0.21353f
C534 Vg28.t4 GND 0.3807f
C535 Vg28.t5 GND 0.3807f
C536 Vg28.n59 GND 0.1072f
C537 Vg28.n60 GND 0.2206f
C538 Vg28.t21 GND 0.05706f
C539 Vg28.t22 GND 0.05706f
C540 Vg28.n61 GND 0.24654f
C541 Vg28.t23 GND 0.05706f
C542 Vg28.t24 GND 0.05706f
C543 Vg28.n62 GND 0.24655f
C544 Vg28.t25 GND 0.05706f
C545 Vg28.t26 GND 0.05706f
C546 Vg28.n63 GND 0.29121f
C547 Vg28.n64 GND 0.43317f
C548 Vg28.n65 GND 0.2546f
C549 a_40258_n12.n0 GND 0.78573f
C550 a_40258_n12.n1 GND 0.10127f
C551 a_40258_n12.n4 GND 0.10102f
C552 a_40258_n12.n5 GND 0.13267f
C553 a_40258_n12.n8 GND 0.10781f
C554 a_40258_n12.n9 GND 0.11864f
C555 a_40258_n12.n10 GND 0.10936f
C556 a_40258_n12.n11 GND 0.11057f
C557 a_40258_n12.n12 GND 0.11017f
C558 a_40258_n12.n13 GND 0.14159f
C559 a_40258_n12.t6 GND 0.11596f
C560 a_40258_n12.t8 GND 0.11596f
C561 a_40258_n12.n14 GND 0.06286f
C562 a_40258_n12.n15 GND 0.13879f
C563 a_40258_n12.t13 GND 0.19778f
C564 a_40258_n12.t0 GND 0.19778f
C565 a_40258_n12.n16 GND 0.08341f
C566 a_40258_n12.t14 GND 0.19778f
C567 a_40258_n12.t1 GND 0.19778f
C568 a_40258_n12.n17 GND 0.0939f
C569 a_40258_n12.n18 GND 0.38298f
C570 a_40258_n12.t2 GND 0.27686f
C571 a_40258_n12.t4 GND 0.19138f
C572 a_40258_n12.n19 GND 0.03071f
C573 a_40258_n12.n20 GND 0.03383f
C574 a_40258_n12.n21 GND 0.11608f
C575 a_40258_n12.n22 GND 0.13928f
C576 a_40258_n12.t10 GND 0.17882f
C577 a_40258_n12.t12 GND 0.13422f
C578 GND.t5 GND 0.44092f
C579 GND.t44 GND 24.68145f
C580 GND.t11 GND 1.35496f
C581 GND.t1 GND 3.94744f
C582 VDD.t10 GND 0.78074f
C583 VDD.n0 GND 0.07634f
C584 VDD.n1 GND 4.08828f
C585 VDD.n2 GND 0.11749f
C586 VDD.n3 GND 0.82141f
C587 VDD.n4 GND 3.02632f
C588 VDD.n5 GND 1.42643f
C589 VDD.n6 GND 0.60304f
C590 VDD.n7 GND 0.82475f
C591 VDD.n8 GND 0.20632f
C592 VDD.n9 GND 0.41229f
C593 VDD.n10 GND 0.47396f
C594 VDD.n11 GND 0.08827f
C595 VDD.n12 GND 4.34637f
C596 VDD.n13 GND 6.03785f
C597 VDD.n14 GND 10.1833f
C598 VDD.n15 GND 1.35047f
C599 VDD.n16 GND 1.55645f
C600 VDD.n17 GND 2.95924f
C601 VDD.t24 GND 3.14665f
C602 VDD.n18 GND 0.07059f
C603 VDD.n19 GND 6.37185f
C604 VDD.n20 GND 3.41239f
C605 VDD.n21 GND 2.42038f
C606 VDD.n22 GND 0.86151f
C607 VDD.n23 GND 7.5561f
C608 VDD.t50 GND 0.0436f
C609 VDD.n24 GND 0.14717f
C610 VDD.n25 GND 3.36744f
C611 VDD.t52 GND 4.7343f
C612 VDD.n26 GND 0.6753f
C613 VDD.n27 GND 0.48717f
C614 VDD.n28 GND 0.01569f
C615 VDD.n29 GND 0.07035f
C616 VDD.t49 GND 0.90683f
C617 VDD.n31 GND 0.62944f
C618 VDD.n32 GND 0.07035f
C619 VDD.n34 GND 0.62944f
C620 VDD.n35 GND 0.48926f
C621 VDD.n36 GND 0.40317f
C622 VDD.n37 GND 0.15427f
C623 VDD.n38 GND 0.07035f
C624 VDD.n39 GND 0.07035f
C625 VDD.n40 GND 0.40421f
C626 VDD.n41 GND 0.59405f
C627 VDD.n42 GND 0.62944f
C628 VDD.t51 GND 0.90683f
C629 VDD.n45 GND 0.62944f
C630 VDD.n46 GND 0.02356f
C631 VDD.n47 GND 0.80667f
C632 VDD.n48 GND 10.4989f
C633 VDD.n49 GND 5.08276f
C634 VDD.n50 GND 0.09432f
C635 VDD.n51 GND 0.09348f
C636 VDD.n52 GND 0.09434f
C637 VDD.t3 GND 1.30334f
C638 VDD.t55 GND 1.23004f
C639 VDD.t53 GND 2.22293f
C640 VDD.n53 GND 0.13508f
C641 VDD.n54 GND 2.14852f
C642 VDD.n55 GND 0.16274f
C643 VDD.n56 GND 0.1125f
C644 VDD.t2 GND 3.08045f
C645 VDD.t30 GND -1.15343f
C646 VDD.n57 GND 0.12972f
C647 VDD.n58 GND 0.97265f
C648 VDD.n59 GND 1.64681f
C649 VDD.n60 GND 3.85986f
C650 VDD.n61 GND 0.06645f
C651 VDD.n62 GND 1.71482f
C652 VDD.n63 GND 0.08765f
C653 VDD.n64 GND 0.07608f
C654 VDD.n65 GND 5.53591f
C655 VDD.n66 GND 3.20548f
C656 VDD.n67 GND 0.06681f
C657 VDD.n68 GND 0.1085f
C658 VDD.n69 GND 0.09755f
C659 VDD.n70 GND 0.11749f
C660 VDD.n71 GND 0.04926f
C661 VDD.t70 GND 0.92737f
C662 VDD.t68 GND 0.85406f
C663 VDD.t90 GND 0.85406f
C664 VDD.n72 GND 0.09597f
C665 VDD.t58 GND 0.85406f
C666 VDD.t69 GND 0.85406f
C667 VDD.n73 GND 0.0743f
C668 VDD.n74 GND 0.3404f
C669 VDD.n75 GND 3.20548f
C670 VDD.n76 GND 0.09755f
C671 VDD.n77 GND 0.08337f
C672 VDD.n78 GND 0.12934f
C673 VDD.n79 GND 0.6768f
C674 VDD.n80 GND 1.61445f
C675 VDD.n81 GND 1.91327f
C676 VDD.n82 GND 0.0767f
C677 VDD.t78 GND 0.54417f
C678 VDD.t20 GND 0.68335f
C679 VDD.t46 GND 0.54417f
C680 VDD.n83 GND 0.80408f
C681 VDD.n84 GND 0.0549f
C682 VDD.t5 GND 0.54417f
C683 VDD.t22 GND 0.68335f
C684 VDD.n85 GND 0.77265f
C685 VDD.t23 GND 0.54059f
C686 VDD.t99 GND 0.43078f
C687 VDD.t97 GND 0.43078f
C688 VDD.n86 GND 0.1424f
C689 VDD.t6 GND 0.43078f
C690 VDD.t57 GND 0.43078f
C691 VDD.n87 GND 0.13413f
C692 VDD.n88 GND 0.42536f
C693 VDD.n89 GND 6.40873f
C694 VDD.n90 GND 8.63275f
C695 VDD.n91 GND 0.07634f
C696 VDD.t56 GND 0.54417f
C697 VDD.t98 GND 0.54417f
C698 VDD.t96 GND 0.63889f
C699 VDD.t13 GND 0.63889f
C700 VDD.n92 GND 0.7336f
C701 VDD.n93 GND 0.0946f
C702 VDD.n94 GND 0.0767f
C703 VDD.n95 GND 0.07634f
C704 VDD.t84 GND 0.54417f
C705 VDD.n96 GND 0.07634f
C706 VDD.n97 GND 3.998f
C707 VDD.n98 GND 2.13813f
C708 VDD.n99 GND 1.7165f
C709 VDD.t29 GND 12.47072f
C710 VDD.n100 GND 0.86151f
C711 VDD.t93 GND 0.68335f
C712 VDD.t85 GND 0.54417f
C713 VDD.t43 GND 0.54417f
C714 VDD.t35 GND 0.54417f
C715 VDD.t39 GND 0.54417f
C716 VDD.t79 GND 0.54417f
C717 VDD.t18 GND 0.54417f
C718 VDD.t65 GND 0.54417f
C719 VDD.t41 GND 0.54417f
C720 VDD.t33 GND 0.54417f
C721 VDD.t37 GND 0.54417f
C722 VDD.t16 GND 0.54417f
C723 VDD.t86 GND 0.18778f
C724 VDD.t44 GND 0.18778f
C725 VDD.n101 GND 0.13317f
C726 VDD.t36 GND 0.18778f
C727 VDD.t40 GND 0.18778f
C728 VDD.n102 GND 0.13322f
C729 VDD.t80 GND 0.18778f
C730 VDD.t19 GND 0.18778f
C731 VDD.n103 GND 0.13324f
C732 VDD.t66 GND 0.18778f
C733 VDD.t42 GND 0.18778f
C734 VDD.n104 GND 0.13322f
C735 VDD.t34 GND 0.18778f
C736 VDD.t38 GND 0.18778f
C737 VDD.n105 GND 0.13318f
C738 VDD.t17 GND 0.18778f
C739 VDD.t64 GND 0.18778f
C740 VDD.n106 GND 0.13318f
C741 VDD.t83 GND 0.18778f
C742 VDD.t89 GND 0.18778f
C743 VDD.n107 GND 0.13317f
C744 VDD.t77 GND 0.18778f
C745 VDD.t62 GND 0.18778f
C746 VDD.n108 GND 0.13322f
C747 VDD.t12 GND 0.18778f
C748 VDD.t9 GND 0.18778f
C749 VDD.n109 GND 0.13317f
C750 VDD.t27 GND 0.18778f
C751 VDD.t60 GND 0.18778f
C752 VDD.n110 GND 0.13313f
C753 VDD.t1 GND 0.18778f
C754 VDD.t32 GND 0.18778f
C755 VDD.n111 GND 0.13323f
C756 VDD.t15 GND 0.18778f
C757 VDD.t92 GND 0.18782f
C758 VDD.n112 GND 0.13987f
C759 VDD.t94 GND 0.29761f
C760 VDD.n113 GND 2.05432f
C761 VDD.n114 GND 1.0387f
C762 VDD.n115 GND 0.21166f
C763 VDD.t91 GND 0.68335f
C764 VDD.t14 GND 0.54417f
C765 VDD.t31 GND 0.54417f
C766 VDD.t0 GND 0.54417f
C767 VDD.t59 GND 0.54417f
C768 VDD.t26 GND 0.54417f
C769 VDD.t8 GND 0.54417f
C770 VDD.t11 GND 0.54417f
C771 VDD.t61 GND 0.54417f
C772 VDD.t76 GND 0.54417f
C773 VDD.t88 GND 0.54417f
C774 VDD.t82 GND 0.54417f
C775 VDD.t63 GND 0.54417f
C776 VDD.n116 GND 0.21166f
C777 VDD.n117 GND 0.54697f
C778 VDD.n118 GND 0.51311f
C779 VDD.n119 GND 0.62944f
C780 VDD.n120 GND 0.62944f
C781 VDD.n121 GND 0.07035f
C782 VDD.t28 GND 0.90683f
C783 VDD.n124 GND 0.07035f
C784 VDD.n125 GND 0.43503f
C785 VDD.n126 GND 3.06449f
C786 VDD.n127 GND 2.32813f
C787 VDD.n128 GND 0.60749f
C788 VDD.n129 GND 1.23576f
C789 VDD.n130 GND 0.60749f
C790 VDD.t101 GND 0.4947f
C791 VDD.t100 GND 0.39276f
C792 VDD.t105 GND 0.39276f
C793 VDD.t104 GND 0.39276f
C794 VDD.t106 GND 0.39276f
C795 VDD.t103 GND 0.39276f
C796 VDD.t95 GND 0.39276f
C797 VDD.t67 GND 0.4947f
C798 VDD.t47 GND 0.39276f
C799 VDD.t45 GND 0.39276f
C800 VDD.t21 GND 0.39276f
C801 VDD.t48 GND 0.39276f
C802 VDD.t102 GND 0.39276f
C803 VDD.t81 GND 0.39276f
C804 VDD.n131 GND 0.14006f
C805 VDD.t87 GND 0.39276f
C806 VDD.n132 GND 0.14006f
C807 VDD.n133 GND 0.27935f
C808 VDD.n134 GND 4.17292f
C809 VDD.n135 GND 6.09988f
C810 VDD.n136 GND 0.07608f
C811 VDD.n137 GND 2.43693f
C812 VDD.n138 GND 1.09661f
C813 VDD.n139 GND 0.04169f
C814 VDD.n140 GND 0.02483f
C815 VDD.n141 GND 0.10202f
C816 VDD.n142 GND 0.03889f
C817 VDD.n143 GND 0.07621f
C818 VDD.n144 GND 0.03889f
C819 VDD.n145 GND 0.06681f
C820 VDD.t4 GND 5.53591f
C821 VDD.n146 GND 0.10939f
C822 VDD.n147 GND 1.43622f
C823 VDD.n148 GND 0.99942f
C824 VDD.t75 GND 0.92737f
C825 VDD.n149 GND 0.13442f
C826 VDD.t72 GND 0.85406f
C827 VDD.t71 GND 0.85406f
C828 VDD.n150 GND 0.09597f
C829 VDD.t74 GND 0.85406f
C830 VDD.t73 GND 0.85406f
C831 VDD.n151 GND 0.0743f
C832 VDD.n152 GND 0.3404f
C833 VDD.n153 GND 1.7243f
C834 VDD.n154 GND 0.10939f
C835 VDD.t7 GND 5.53591f
C836 VDD.n155 GND 0.08827f
C837 VDD.n156 GND 1.34448f
C838 VDD.n157 GND 0.11246f
C839 VDD.n158 GND 0.13839f
C840 VDD.n159 GND 0.04954f
C841 VDD.n160 GND 0.06681f
C842 VDD.n161 GND 3.03749f
C843 VDD.n162 GND 4.51962f
C844 VDD.n163 GND 1.16473f
C845 VDD.n164 GND 0.12812f
C846 VDD.n165 GND 3.65694f
C847 VDD.n166 GND 0.50659f
C848 VDD.n167 GND 0.41998f
C849 VDD.n168 GND 2.6328f
C850 VDD.n169 GND 0.77675f
C851 VDD.n170 GND 0.38707f
C852 VDD.n171 GND 1.32541f
C853 VDD.n172 GND 0.42034f
C854 VDD.n173 GND 1.60135f
C855 VDD.n174 GND 3.27756f
C856 VDD.n175 GND 0.12812f
C857 VDD.n176 GND 2.72056f
C858 VDD.t107 GND 1.9629f
C859 VDD.t54 GND 0.78857f
C860 VDD.t25 GND 1.37849f
C861 VDD.n177 GND 0.05289f
C862 VDD.n178 GND 1.08385f
C863 VDD.n179 GND 1.55645f
C864 VDD.n180 GND 0.02992f
C865 VDD.n181 GND 0.04675f
C866 VDD.n182 GND 0.03902f
C867 VDD.n183 GND 0.98016f
C868 VDD.n184 GND 9.47416f
C869 Vp.n0 GND 0.83024f
C870 Vp.n1 GND 0.82966f
C871 Vp.n2 GND 0.83037f
C872 Vp.n3 GND 1.43009f
C873 Vp.n4 GND 0.48913f
C874 Vp.n5 GND 0.03978f
C875 Vp.n6 GND 1.43423f
C876 Vp.n7 GND 0.83118f
C877 Vp.n8 GND 0.03978f
C878 Vp.n9 GND 0.83007f
C879 Vp.n10 GND 0.03978f
C880 Vp.n11 GND 0.82926f
C881 Vp.n12 GND 0.829f
C882 Vp.n13 GND 0.03978f
C883 Vp.n14 GND 0.83011f
C884 Vp.n15 GND 0.03978f
C885 Vp.n16 GND 0.83078f
C886 Vp.n17 GND 0.83078f
C887 Vp.n18 GND 0.82966f
C888 Vp.n19 GND 1.42651f
C889 Vp.n20 GND 0.95476f
C890 Vp.n21 GND 1.5619f
C891 Vp.n22 GND 1.56317f
C892 Vp.n23 GND 1.56219f
C893 Vp.n24 GND 2.94225f
C894 Vp.n25 GND 0.62073f
C895 Vp.n26 GND 0.04491f
C896 Vp.n27 GND 2.9306f
C897 Vp.n28 GND 1.56336f
C898 Vp.n29 GND 0.04491f
C899 Vp.n30 GND 1.56348f
C900 Vp.n31 GND 0.04491f
C901 Vp.n32 GND 1.56228f
C902 Vp.n33 GND 1.5617f
C903 Vp.n34 GND 0.04491f
C904 Vp.n35 GND 1.56161f
C905 Vp.n36 GND 0.04491f
C906 Vp.n37 GND 1.56307f
C907 Vp.n38 GND 1.56365f
C908 Vp.n39 GND 0.04491f
C909 Vp.n40 GND 1.56377f
C910 Vp.n41 GND 0.04491f
C911 Vp.n42 GND 2.88443f
C912 Vp.n43 GND 0.28235f
C913 Vp.n44 GND 1.56923f
C914 Vn.n0 GND 1.5849f
C915 Vn.n1 GND 1.58796f
C916 Vn.n2 GND 1.58519f
C917 Vn.n3 GND 2.98875f
C918 Vn.n4 GND 0.63021f
C919 Vn.n5 GND 0.0456f
C920 Vn.n6 GND 2.9739f
C921 Vn.n7 GND 1.58638f
C922 Vn.n8 GND 0.0456f
C923 Vn.n9 GND 1.58827f
C924 Vn.n10 GND 0.0456f
C925 Vn.n11 GND 1.58705f
C926 Vn.n12 GND 1.58647f
C927 Vn.n13 GND 0.0456f
C928 Vn.n14 GND 1.5846f
C929 Vn.n15 GND 0.0456f
C930 Vn.n16 GND 1.58608f
C931 Vn.n17 GND 1.58667f
C932 Vn.n18 GND 0.0456f
C933 Vn.n19 GND 1.58857f
C934 Vn.n20 GND 0.0456f
C935 Vn.n21 GND 2.93005f
C936 Vn.n22 GND 0.28692f
C937 Vn.n23 GND 1.63858f
C938 Vn.n24 GND 0.84208f
C939 Vn.n25 GND 0.84322f
C940 Vn.n26 GND 0.84221f
C941 Vn.n27 GND 1.45327f
C942 Vn.n28 GND 0.49661f
C943 Vn.n29 GND 0.04039f
C944 Vn.n30 GND 1.45485f
C945 Vn.n31 GND 0.84303f
C946 Vn.n32 GND 0.04039f
C947 Vn.n33 GND 0.84363f
C948 Vn.n34 GND 0.04039f
C949 Vn.n35 GND 0.8428f
C950 Vn.n36 GND 0.84254f
C951 Vn.n37 GND 0.04039f
C952 Vn.n38 GND 0.84194f
C953 Vn.n39 GND 0.04039f
C954 Vn.n40 GND 0.84262f
C955 Vn.n41 GND 0.84262f
C956 Vn.n42 GND 0.84322f
C957 Vn.n43 GND 1.44963f
C958 Vn.n44 GND 0.87851f
C959 Vout.t0 GND 0.31851p
C960 Vout.t6 GND 0.4226p
C961 Vout.t2 GND 0.4628p
.ends
