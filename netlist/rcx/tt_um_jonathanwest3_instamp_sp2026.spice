* NGSPICE file created from tt_um_jonathanwest3_instamp_sp2026.ext - technology: sky130A

.subckt tt_um_jonathanwest3_instamp_sp2026 clk ena rst_n ua[0] ua[1] ua[2] ua[3] ua[4]
+ ua[5] ua[6] ua[7] ui_in[0] ui_in[1] ui_in[2] ui_in[3] ui_in[4] ui_in[5] ui_in[6]
+ ui_in[7] uio_in[0] uio_in[1] uio_in[2] uio_in[3] uio_in[4] uio_in[5] uio_in[6] uio_in[7]
+ uio_oe[0] uio_oe[1] uio_oe[2] uio_oe[3] uio_oe[4] uio_oe[5] uio_oe[6] uio_oe[7]
+ uio_out[0] uio_out[1] uio_out[2] uio_out[3] uio_out[4] uio_out[5] uio_out[6] uio_out[7]
+ uo_out[0] uo_out[1] uo_out[2] uo_out[3] uo_out[4] uo_out[5] uo_out[6] uo_out[7]
+ VDPWR VGND VAPWR
R0 uio_out[1] VGND sky130_fd_pr__res_generic_m3 w=0.3 l=0.3
R1 ui_in[2] VGND sky130_fd_pr__res_generic_m3 w=0.3 l=0.3
R2 uo_out[7] VGND sky130_fd_pr__res_generic_m3 w=0.3 l=0.3
R3 ui_in[1] VGND sky130_fd_pr__res_generic_m3 w=0.3 l=0.3
R4 uo_out[0] VGND sky130_fd_pr__res_generic_m3 w=0.3 l=0.3
R5 uio_in[3] VGND sky130_fd_pr__res_generic_m3 w=0.3 l=0.3
R6 VGND ua[6] sky130_fd_pr__res_generic_m3 w=0.3 l=0.3
R7 VGND ua[7] sky130_fd_pr__res_generic_m3 w=0.3 l=0.3
R8 uio_oe[4] VGND sky130_fd_pr__res_generic_m3 w=0.3 l=0.3
R9 uio_in[2] VGND sky130_fd_pr__res_generic_m3 w=0.3 l=0.3
R10 ui_in[7] VGND sky130_fd_pr__res_generic_m3 w=0.3 l=0.3
R11 uo_out[1] VGND sky130_fd_pr__res_generic_m3 w=0.3 l=0.3
R12 uio_oe[2] VGND sky130_fd_pr__res_generic_m3 w=0.3 l=0.3
R13 uo_out[3] VGND sky130_fd_pr__res_generic_m3 w=0.3 l=0.3
R14 ui_in[5] VGND sky130_fd_pr__res_generic_m3 w=0.3 l=0.3
R15 uio_out[5] VGND sky130_fd_pr__res_generic_m3 w=0.3 l=0.3
R16 uio_in[7] VGND sky130_fd_pr__res_generic_m3 w=0.3 l=0.3
R17 rst_n VGND sky130_fd_pr__res_generic_m3 w=0.3 l=0.3
R18 ena VGND sky130_fd_pr__res_generic_m3 w=0.3 l=0.3
R19 uio_in[5] VGND sky130_fd_pr__res_generic_m3 w=0.3 l=0.3
R20 uio_in[0] VGND sky130_fd_pr__res_generic_m3 w=0.3 l=0.3
R21 uio_oe[3] VGND sky130_fd_pr__res_generic_m3 w=0.3 l=0.3
R22 uio_out[4] VGND sky130_fd_pr__res_generic_m3 w=0.3 l=0.3
R23 uo_out[6] VGND sky130_fd_pr__res_generic_m3 w=0.3 l=0.3
R24 uo_out[4] VGND sky130_fd_pr__res_generic_m3 w=0.3 l=0.3
R25 uio_oe[6] VGND sky130_fd_pr__res_generic_m3 w=0.3 l=0.3
R26 uo_out[5] VGND sky130_fd_pr__res_generic_m3 w=0.3 l=0.3
R27 uio_in[6] VGND sky130_fd_pr__res_generic_m3 w=0.3 l=0.3
R28 ui_in[4] VGND sky130_fd_pr__res_generic_m3 w=0.3 l=0.3
R29 uio_out[2] VGND sky130_fd_pr__res_generic_m3 w=0.3 l=0.3
R30 uio_out[3] VGND sky130_fd_pr__res_generic_m3 w=0.3 l=0.3
R31 uio_out[6] VGND sky130_fd_pr__res_generic_m3 w=0.3 l=0.3
R32 uio_oe[5] VGND sky130_fd_pr__res_generic_m3 w=0.3 l=0.3
R33 uio_oe[1] VGND sky130_fd_pr__res_generic_m3 w=0.3 l=0.3
R34 uio_out[7] VGND sky130_fd_pr__res_generic_m3 w=0.3 l=0.3
R35 ui_in[6] VGND sky130_fd_pr__res_generic_m3 w=0.3 l=0.3
R36 ui_in[3] VGND sky130_fd_pr__res_generic_m3 w=0.3 l=0.3
R37 uio_oe[0] VGND sky130_fd_pr__res_generic_m3 w=0.3 l=0.3
R38 uio_in[4] VGND sky130_fd_pr__res_generic_m3 w=0.3 l=0.3
R39 uio_in[1] VGND sky130_fd_pr__res_generic_m3 w=0.3 l=0.3
R40 clk VGND sky130_fd_pr__res_generic_m3 w=0.3 l=0.3
R41 ui_in[0] VGND sky130_fd_pr__res_generic_m3 w=0.3 l=0.3
R42 uio_oe[7] VGND sky130_fd_pr__res_generic_m3 w=0.3 l=0.3
R43 uio_out[0] VGND sky130_fd_pr__res_generic_m3 w=0.3 l=0.3
R44 uo_out[2] VGND sky130_fd_pr__res_generic_m3 w=0.3 l=0.3
C0 uio_oe[7] uio_oe[6] 0.07305f
C1 uio_oe[7] VGND 0.04558f
C2 uio_oe[6] uio_oe[5] 0.07539f
C3 uio_oe[6] VGND 0.04938f
C4 uio_oe[5] VGND 0.05044f
C5 uio_oe[5] uio_oe[4] 0.07682f
C6 VGND uio_oe[4] 0.05013f
C7 VGND uio_oe[3] 0.05071f
C8 VGND uio_oe[2] 0.04851f
C9 VGND uio_oe[1] 0.05237f
C10 VGND uio_oe[0] 0.05102f
C11 VGND uio_out[7] 0.04806f
C12 VGND uio_out[6] 0.0541f
C13 VGND uio_out[5] 0.05307f
C14 VGND uio_out[4] 0.04919f
C15 VGND uio_out[3] 0.04781f
C16 VGND uio_out[1] 0.04668f
C17 VGND uio_out[2] 0.05289f
C18 VGND uio_out[0] 0.04793f
C19 VGND uo_out[7] 0.05231f
C20 VGND uo_out[6] 0.04801f
C21 VGND uo_out[5] 0.04886f
C22 VGND uo_out[4] 0.04549f
C23 VGND uo_out[3] 0.04782f
C24 VGND uo_out[2] 0.04856f
C25 VGND uo_out[1] 0.04819f
C26 VGND uo_out[0] 0.0487f
C27 VGND uio_in[7] 0.04647f
C28 VGND uio_in[2] 0.0435f
C29 VGND uio_in[6] 0.04806f
C30 VGND uio_in[5] 0.04662f
C31 VGND uio_in[4] 0.04774f
C32 VGND uio_in[3] 0.04931f
C33 VGND uio_in[1] 0.04868f
C34 VGND ui_in[7] 0.04407f
C35 VGND uio_in[0] 0.04947f
C36 VGND ui_in[6] 0.0463f
C37 VGND ui_in[5] 0.04927f
C38 VGND ui_in[4] 0.0473f
C39 VGND ui_in[3] 0.04739f
C40 VGND ui_in[2] 0.04406f
C41 VGND ui_in[1] 0.0472f
C42 VGND ui_in[0] 0.04615f
C43 VGND rst_n 0.05073f
C44 VGND clk 0.04762f
C45 VGND ena 0.04299f
C46 VGND ua[7] 0.03061f
C47 VGND ua[6] 0.04621f
C48 VGND VDPWR 12.9328f
C49 VGND VAPWR 12.9489f
C50 uio_oe[4] uio_oe[3] 0.07651f
C51 uio_oe[3] uio_oe[2] 0.07585f
C52 uio_oe[2] uio_oe[1] 0.07565f
C53 uio_oe[1] uio_oe[0] 0.07592f
C54 uio_oe[0] uio_out[7] 0.07698f
C55 uio_out[7] uio_out[6] 0.07426f
C56 uio_out[6] uio_out[5] 0.07747f
C57 uio_out[5] uio_out[4] 0.07302f
C58 uio_out[4] uio_out[3] 0.07608f
C59 uio_out[3] uio_out[2] 0.07682f
C60 uio_out[1] uio_out[2] 0.07382f
C61 uio_out[1] uio_out[0] 0.07756f
C62 uio_out[0] uo_out[7] 0.07618f
C63 uo_out[7] uo_out[6] 0.07626f
C64 uo_out[6] uo_out[5] 0.07688f
C65 uo_out[5] uo_out[4] 0.07665f
C66 uo_out[4] uo_out[3] 0.07625f
C67 uo_out[3] uo_out[2] 0.07736f
C68 uo_out[2] uo_out[1] 0.07791f
C69 uo_out[1] uo_out[0] 0.07812f
C70 uo_out[0] uio_in[7] 0.07637f
C71 uio_in[7] uio_in[6] 0.07817f
C72 uio_in[2] uio_in[3] 0.07491f
C73 uio_in[2] uio_in[1] 0.07658f
C74 uio_in[6] uio_in[5] 0.07684f
C75 uio_in[5] uio_in[4] 0.07663f
C76 uio_in[4] uio_in[3] 0.07554f
C77 uio_in[1] uio_in[0] 0.07796f
C78 ui_in[7] uio_in[0] 0.07596f
C79 ui_in[7] ui_in[6] 0.07813f
C80 ui_in[6] ui_in[5] 0.07707f
C81 ui_in[5] ui_in[4] 0.07725f
C82 ui_in[4] ui_in[3] 0.07837f
C83 ui_in[3] ui_in[2] 0.07655f
C84 ui_in[2] ui_in[1] 0.07575f
C85 ui_in[1] ui_in[0] 0.078f
C86 ui_in[0] rst_n 0.07702f
C87 rst_n clk 0.0775f
C88 clk ena 0.07585f
C89 ua[7] VDPWR 0.03857f
C90 ua[0] w_186_0# 0.14696f
C91 ua[1] w_186_0# 0.14696f
C92 ua[2] w_186_0# 0.14696f
C93 ua[3] w_186_0# 0.14696f
C94 ua[4] w_186_0# 0.14696f
C95 ua[5] w_186_0# 0.14696f
C96 VAPWR w_186_0# 12.528f
C97 VDPWR w_186_0# 12.4896f
C98 ua[6] w_186_0# 0.35428f
C99 ua[7] w_186_0# 0.30948f
C100 ena w_186_0# 0.24464f
C101 clk w_186_0# 0.18295f
C102 rst_n w_186_0# 0.18698f
C103 ui_in[0] w_186_0# 0.18883f
C104 ui_in[1] w_186_0# 0.1877f
C105 ui_in[2] w_186_0# 0.18553f
C106 ui_in[3] w_186_0# 0.1849f
C107 ui_in[4] w_186_0# 0.18813f
C108 ui_in[5] w_186_0# 0.18737f
C109 ui_in[6] w_186_0# 0.18817f
C110 uio_in[0] w_186_0# 0.18815f
C111 ui_in[7] w_186_0# 0.19029f
C112 uio_in[1] w_186_0# 0.18814f
C113 uio_in[3] w_186_0# 0.18664f
C114 uio_in[4] w_186_0# 0.18256f
C115 uio_in[5] w_186_0# 0.18396f
C116 uio_in[6] w_186_0# 0.18406f
C117 uio_in[2] w_186_0# 0.19054f
C118 uio_in[7] w_186_0# 0.1897f
C119 uo_out[0] w_186_0# 0.18673f
C120 uo_out[1] w_186_0# 0.18803f
C121 uo_out[2] w_186_0# 0.18819f
C122 uo_out[3] w_186_0# 0.18821f
C123 uo_out[4] w_186_0# 0.18672f
C124 uo_out[5] w_186_0# 0.18685f
C125 uo_out[6] w_186_0# 0.18656f
C126 uo_out[7] w_186_0# 0.18755f
C127 uio_out[0] w_186_0# 0.18726f
C128 uio_out[2] w_186_0# 0.18474f
C129 uio_out[1] w_186_0# 0.18975f
C130 uio_out[3] w_186_0# 0.18884f
C131 uio_out[4] w_186_0# 0.18805f
C132 uio_out[5] w_186_0# 0.1827f
C133 uio_out[6] w_186_0# 0.18768f
C134 uio_out[7] w_186_0# 0.18558f
C135 uio_oe[0] w_186_0# 0.18781f
C136 uio_oe[1] w_186_0# 0.18645f
C137 uio_oe[2] w_186_0# 0.18701f
C138 uio_oe[3] w_186_0# 0.18557f
C139 uio_oe[4] w_186_0# 0.18546f
C140 VGND w_186_0# 18.96929f
C141 uio_oe[5] w_186_0# 0.18648f
C142 uio_oe[6] w_186_0# 0.18461f
C143 uio_oe[7] w_186_0# 0.23997f
.ends
