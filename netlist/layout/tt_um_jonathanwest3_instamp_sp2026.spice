* NGSPICE file created from tt_um_jonathanwest3_instamp_sp2026.ext - technology: sky130A

.subckt sky130_fd_pr__res_generic_m3_5VRV4L R1 R2
R0 R1 R2 sky130_fd_pr__res_generic_m3 w=0.3 l=0.3
.ends

.subckt sky130_fd_pr__res_high_po_0p35_5E7VKC B R1 R2
X0 R2 R1 B sky130_fd_pr__res_high_po_0p35 l=76.36
.ends

.subckt sky130_fd_pr__res_high_po_0p35_T9W6LG B R1 R2
X0 R2 R1 B sky130_fd_pr__res_high_po_0p35 l=51.36
.ends

.subckt sky130_fd_pr__pfet_g5v0d10v5_K6B4C5 a_416_n1097# a_n358_n1097# a_n674_n1000#
+ a_n616_n1097# a_358_n1000# a_n158_n1000# a_616_n1000# a_n416_n1000# a_n100_n1097#
+ w_n874_n1297# a_158_n1097# a_100_n1000#
X0 a_n416_n1000# a_n616_n1097# a_n674_n1000# w_n874_n1297# sky130_fd_pr__pfet_g5v0d10v5 ad=1.45 pd=10.29 as=2.9 ps=20.58 w=10 l=1
X1 a_n158_n1000# a_n358_n1097# a_n416_n1000# w_n874_n1297# sky130_fd_pr__pfet_g5v0d10v5 ad=1.45 pd=10.29 as=1.45 ps=10.29 w=10 l=1
X2 a_358_n1000# a_158_n1097# a_100_n1000# w_n874_n1297# sky130_fd_pr__pfet_g5v0d10v5 ad=1.45 pd=10.29 as=1.45 ps=10.29 w=10 l=1
X3 a_616_n1000# a_416_n1097# a_358_n1000# w_n874_n1297# sky130_fd_pr__pfet_g5v0d10v5 ad=2.9 pd=20.58 as=1.45 ps=10.29 w=10 l=1
X4 a_100_n1000# a_n100_n1097# a_n158_n1000# w_n874_n1297# sky130_fd_pr__pfet_g5v0d10v5 ad=1.45 pd=10.29 as=1.45 ps=10.29 w=10 l=1
.ends

.subckt sky130_fd_pr__pfet_g5v0d10v5_4QM9AE a_n866_n1000# a_308_n1097# a_n250_n1097#
+ a_n808_n1097# a_250_n1000# a_n1366_n1097# w_n1624_n1297# a_808_n1000# a_866_n1097#
+ a_n308_n1000# a_1366_n1000# a_n1424_n1000#
X0 a_250_n1000# a_n250_n1097# a_n308_n1000# w_n1624_n1297# sky130_fd_pr__pfet_g5v0d10v5 ad=1.45 pd=10.29 as=1.45 ps=10.29 w=10 l=2.5
X1 a_n308_n1000# a_n808_n1097# a_n866_n1000# w_n1624_n1297# sky130_fd_pr__pfet_g5v0d10v5 ad=1.45 pd=10.29 as=1.45 ps=10.29 w=10 l=2.5
X2 a_808_n1000# a_308_n1097# a_250_n1000# w_n1624_n1297# sky130_fd_pr__pfet_g5v0d10v5 ad=1.45 pd=10.29 as=1.45 ps=10.29 w=10 l=2.5
X3 a_n866_n1000# a_n1366_n1097# a_n1424_n1000# w_n1624_n1297# sky130_fd_pr__pfet_g5v0d10v5 ad=1.45 pd=10.29 as=2.9 ps=20.58 w=10 l=2.5
X4 a_1366_n1000# a_866_n1097# a_808_n1000# w_n1624_n1297# sky130_fd_pr__pfet_g5v0d10v5 ad=2.9 pd=20.58 as=1.45 ps=10.29 w=10 l=2.5
.ends

.subckt m11_12 G D S m1_n836_22394#
Xsky130_fd_pr__pfet_g5v0d10v5_K6B4C5_0 G G m1_n836_22394# G m1_n836_22394# m1_n836_22394#
+ D D G S G D sky130_fd_pr__pfet_g5v0d10v5_K6B4C5
Xsky130_fd_pr__pfet_g5v0d10v5_4QM9AE_0 m1_n836_22394# G G G m1_n836_22394# G S S G
+ S m1_n836_22394# S sky130_fd_pr__pfet_g5v0d10v5_4QM9AE
.ends

.subckt sky130_fd_pr__nfet_g5v0d10v5_VXNDUF B D S G
X0 S G D B sky130_fd_pr__nfet_g5v0d10v5 ad=0.435 pd=3.58 as=0.435 ps=3.58 w=1.5 l=5
.ends

.subckt sky130_fd_pr__pfet_g5v0d10v5_4KCRW8 B D S G
X0 S G D B sky130_fd_pr__pfet_g5v0d10v5 ad=1.16 pd=8.58 as=1.16 ps=8.58 w=4 l=5
.ends

.subckt sky130_fd_pr__pfet_g5v0d10v5_93K9QQ a_n200_n1417# a_200_n1320# a_n658_n1417#
+ a_658_n1320# w_n916_n1617# a_258_n1417# a_n716_n1320# a_n258_n1320#
X0 a_200_n1320# a_n200_n1417# a_n258_n1320# w_n916_n1617# sky130_fd_pr__pfet_g5v0d10v5 ad=1.914 pd=13.49 as=1.914 ps=13.49 w=13.2 l=2
X1 a_n258_n1320# a_n658_n1417# a_n716_n1320# w_n916_n1617# sky130_fd_pr__pfet_g5v0d10v5 ad=1.914 pd=13.49 as=3.828 ps=26.98 w=13.2 l=2
X2 a_658_n1320# a_258_n1417# a_200_n1320# w_n916_n1617# sky130_fd_pr__pfet_g5v0d10v5 ad=3.828 pd=26.98 as=1.914 ps=13.49 w=13.2 l=2
.ends

.subckt sky130_fd_pr__pfet_g5v0d10v5_QAVCZF a_500_n1000# a_n1558_n1097# w_n1816_n1297#
+ a_n558_n1000# a_1558_n1000# a_n500_n1097# a_n1616_n1000# a_558_n1097#
X0 a_500_n1000# a_n500_n1097# a_n558_n1000# w_n1816_n1297# sky130_fd_pr__pfet_g5v0d10v5 ad=1.45 pd=10.29 as=1.45 ps=10.29 w=10 l=5
X1 a_n558_n1000# a_n1558_n1097# a_n1616_n1000# w_n1816_n1297# sky130_fd_pr__pfet_g5v0d10v5 ad=1.45 pd=10.29 as=2.9 ps=20.58 w=10 l=5
X2 a_1558_n1000# a_558_n1097# a_500_n1000# w_n1816_n1297# sky130_fd_pr__pfet_g5v0d10v5 ad=2.9 pd=20.58 as=1.45 ps=10.29 w=10 l=5
.ends

.subckt m07_08 G D S
Xsky130_fd_pr__pfet_g5v0d10v5_93K9QQ_0 G m1_29362_10250# G D S G m1_29362_10250# D
+ sky130_fd_pr__pfet_g5v0d10v5_93K9QQ
Xsky130_fd_pr__pfet_g5v0d10v5_QAVCZF_0 S G S m1_29362_10250# m1_29362_10250# G S G
+ sky130_fd_pr__pfet_g5v0d10v5_QAVCZF
.ends

.subckt sky130_fd_pr__nfet_g5v0d10v5_T8Q8WP a_258_n1518# a_1116_n1430# a_1574_n1430#
+ a_200_n1430# a_n1632_n1430# a_658_n1430# a_n1116_n1518# a_n1174_n1430# a_n1574_n1518#
+ a_n716_n1430# a_1174_n1518# a_n200_n1518# a_716_n1518# a_n1768_n1652# a_n258_n1430#
+ a_n658_n1518#
X0 a_1574_n1430# a_1174_n1518# a_1116_n1430# a_n1768_n1652# sky130_fd_pr__nfet_g5v0d10v5 ad=4.147 pd=29.18 as=2.0735 ps=14.59 w=14.3 l=2
X1 a_n1174_n1430# a_n1574_n1518# a_n1632_n1430# a_n1768_n1652# sky130_fd_pr__nfet_g5v0d10v5 ad=2.0735 pd=14.59 as=4.147 ps=29.18 w=14.3 l=2
X2 a_200_n1430# a_n200_n1518# a_n258_n1430# a_n1768_n1652# sky130_fd_pr__nfet_g5v0d10v5 ad=2.0735 pd=14.59 as=2.0735 ps=14.59 w=14.3 l=2
X3 a_n258_n1430# a_n658_n1518# a_n716_n1430# a_n1768_n1652# sky130_fd_pr__nfet_g5v0d10v5 ad=2.0735 pd=14.59 as=2.0735 ps=14.59 w=14.3 l=2
X4 a_n716_n1430# a_n1116_n1518# a_n1174_n1430# a_n1768_n1652# sky130_fd_pr__nfet_g5v0d10v5 ad=2.0735 pd=14.59 as=2.0735 ps=14.59 w=14.3 l=2
X5 a_658_n1430# a_258_n1518# a_200_n1430# a_n1768_n1652# sky130_fd_pr__nfet_g5v0d10v5 ad=2.0735 pd=14.59 as=2.0735 ps=14.59 w=14.3 l=2
X6 a_1116_n1430# a_716_n1518# a_658_n1430# a_n1768_n1652# sky130_fd_pr__nfet_g5v0d10v5 ad=2.0735 pd=14.59 as=2.0735 ps=14.59 w=14.3 l=2
.ends

.subckt sky130_fd_pr__nfet_g5v0d10v5_XPP34T a_500_n1000# a_n694_n1222# a_n500_n1088#
+ a_n558_n1000#
X0 a_500_n1000# a_n500_n1088# a_n558_n1000# a_n694_n1222# sky130_fd_pr__nfet_g5v0d10v5 ad=2.9 pd=20.58 as=2.9 ps=20.58 w=10 l=5
.ends

.subckt m15_16 D m1_656_n232# G S
Xsky130_fd_pr__nfet_g5v0d10v5_T8Q8WP_0 G D m1_656_n232# D D m1_656_n232# G m1_656_n232#
+ G D G G G S m1_656_n232# G sky130_fd_pr__nfet_g5v0d10v5_T8Q8WP
Xsky130_fd_pr__nfet_g5v0d10v5_XPP34T_0 S S G m1_656_n232# sky130_fd_pr__nfet_g5v0d10v5_XPP34T
.ends

.subckt sky130_fd_pr__nfet_g5v0d10v5_EQJBSH a_n852_n888# a_n716_n666# a_n258_n666#
+ a_n658_n754#
X0 a_n716_n666# a_n658_n754# a_n258_n666# a_n852_n888# sky130_fd_pr__nfet_g5v0d10v5 ad=0.9657 pd=6.95 as=0.9657 ps=6.95 w=6.66 l=2
X1 a_n258_n666# a_n658_n754# a_n716_n666# a_n852_n888# sky130_fd_pr__nfet_g5v0d10v5 ad=1.9314 pd=13.9 as=0.9657 ps=6.95 w=6.66 l=2
X2 a_n258_n666# a_n658_n754# a_n716_n666# a_n852_n888# sky130_fd_pr__nfet_g5v0d10v5 ad=0.9657 pd=6.95 as=1.9314 ps=13.9 w=6.66 l=2
.ends

.subckt m31_32 D G S
Xsky130_fd_pr__nfet_g5v0d10v5_EQJBSH_0 S D m1_21854_12984# G sky130_fd_pr__nfet_g5v0d10v5_EQJBSH
Xsky130_fd_pr__nfet_g5v0d10v5_XPP34T_0 S S G m1_21854_12984# sky130_fd_pr__nfet_g5v0d10v5_XPP34T
.ends

.subckt sky130_fd_pr__pfet_g5v0d10v5_FMWM9G a_n1582_n2319# w_n1840_n2519# a_n1282_n2222#
X0 a_n1282_n2222# a_n1582_n2319# w_n1840_n2519# w_n1840_n2519# sky130_fd_pr__pfet_g5v0d10v5 ad=6.4438 pd=45.02 as=3.2219 ps=22.51 w=22.22 l=1.5
X1 a_n1282_n2222# a_n1582_n2319# w_n1840_n2519# w_n1840_n2519# sky130_fd_pr__pfet_g5v0d10v5 ad=3.2219 pd=22.51 as=3.2219 ps=22.51 w=22.22 l=1.5
X2 a_n1282_n2222# a_n1582_n2319# w_n1840_n2519# w_n1840_n2519# sky130_fd_pr__pfet_g5v0d10v5 ad=3.2219 pd=22.51 as=3.2219 ps=22.51 w=22.22 l=1.5
X3 a_n1282_n2222# a_n1582_n2319# w_n1840_n2519# w_n1840_n2519# sky130_fd_pr__pfet_g5v0d10v5 ad=3.2219 pd=22.51 as=3.2219 ps=22.51 w=22.22 l=1.5
X4 a_n1282_n2222# a_n1582_n2319# w_n1840_n2519# w_n1840_n2519# sky130_fd_pr__pfet_g5v0d10v5 ad=3.2219 pd=22.51 as=6.4438 ps=45.02 w=22.22 l=1.5
X5 w_n1840_n2519# a_n1582_n2319# a_n1282_n2222# w_n1840_n2519# sky130_fd_pr__pfet_g5v0d10v5 ad=3.2219 pd=22.51 as=3.2219 ps=22.51 w=22.22 l=1.5
X6 w_n1840_n2519# a_n1582_n2319# a_n1282_n2222# w_n1840_n2519# sky130_fd_pr__pfet_g5v0d10v5 ad=3.2219 pd=22.51 as=3.2219 ps=22.51 w=22.22 l=1.5
X7 w_n1840_n2519# a_n1582_n2319# a_n1282_n2222# w_n1840_n2519# sky130_fd_pr__pfet_g5v0d10v5 ad=3.2219 pd=22.51 as=3.2219 ps=22.51 w=22.22 l=1.5
X8 w_n1840_n2519# a_n1582_n2319# a_n1282_n2222# w_n1840_n2519# sky130_fd_pr__pfet_g5v0d10v5 ad=3.2219 pd=22.51 as=3.2219 ps=22.51 w=22.22 l=1.5
.ends

.subckt m09_10 D10 D9 G9 G10 S
Xsky130_fd_pr__pfet_g5v0d10v5_FMWM9G_0 G9 S D9 sky130_fd_pr__pfet_g5v0d10v5_FMWM9G
Xsky130_fd_pr__pfet_g5v0d10v5_FMWM9G_1 G10 S D10 sky130_fd_pr__pfet_g5v0d10v5_FMWM9G
.ends

.subckt sky130_fd_pr__nfet_g5v0d10v5_JNX2ZR a_n716_n333# a_n258_n333# a_n658_n421#
+ a_658_n333# a_258_n421# a_n200_n421# a_200_n333# a_n852_n555#
X0 a_200_n333# a_n200_n421# a_n258_n333# a_n852_n555# sky130_fd_pr__nfet_g5v0d10v5 ad=0.48285 pd=3.62 as=0.48285 ps=3.62 w=3.33 l=2
X1 a_658_n333# a_258_n421# a_200_n333# a_n852_n555# sky130_fd_pr__nfet_g5v0d10v5 ad=0.9657 pd=7.24 as=0.48285 ps=3.62 w=3.33 l=2
X2 a_n258_n333# a_n658_n421# a_n716_n333# a_n852_n555# sky130_fd_pr__nfet_g5v0d10v5 ad=0.48285 pd=3.62 as=0.9657 ps=7.24 w=3.33 l=2
.ends

.subckt sky130_fd_pr__nfet_g5v0d10v5_Y3KDPX B D S G m1_n1743_314# m1_n2199_n472#
X0 S G D B sky130_fd_pr__nfet_g5v0d10v5 ad=1.45 pd=10.58 as=1.45 ps=10.58 w=5 l=5
.ends

.subckt m01_02 G D S
Xsky130_fd_pr__nfet_g5v0d10v5_JNX2ZR_0 D sky130_fd_pr__nfet_g5v0d10v5_Y3KDPX_0/D G
+ sky130_fd_pr__nfet_g5v0d10v5_Y3KDPX_0/D G G D S sky130_fd_pr__nfet_g5v0d10v5_JNX2ZR
Xsky130_fd_pr__nfet_g5v0d10v5_Y3KDPX_0 S sky130_fd_pr__nfet_g5v0d10v5_Y3KDPX_0/D S
+ G sky130_fd_pr__nfet_g5v0d10v5_Y3KDPX_0/D D sky130_fd_pr__nfet_g5v0d10v5_Y3KDPX
.ends

.subckt sky130_fd_pr__pfet_g5v0d10v5_UMEKA9 a_1314_n1500# a_524_n1500# a_1156_n1500#
+ a_1630_n1500# a_366_n1500# a_840_n1500# a_1472_n1500# a_1946_n1500# w_n2204_n1797#
+ a_682_n1500# a_n108_n1500# a_1788_n1500# a_n1214_n1500# a_998_n1500# a_n1056_n1500#
+ a_n424_n1500# a_n1530_n1500# a_n266_n1500# a_n1372_n1500# a_n740_n1500# a_n1846_n1500#
+ a_n582_n1500# a_n1688_n1500# a_n898_n1500# a_n2004_n1500# a_50_n1500# a_n1946_n1597#
+ a_208_n1500#
X0 a_366_n1500# a_n1946_n1597# a_208_n1500# w_n2204_n1797# sky130_fd_pr__pfet_g5v0d10v5 ad=2.175 pd=15.29 as=2.175 ps=15.29 w=15 l=0.5
X1 a_50_n1500# a_n1946_n1597# a_n108_n1500# w_n2204_n1797# sky130_fd_pr__pfet_g5v0d10v5 ad=2.175 pd=15.29 as=2.175 ps=15.29 w=15 l=0.5
X2 a_n1214_n1500# a_n1946_n1597# a_n1372_n1500# w_n2204_n1797# sky130_fd_pr__pfet_g5v0d10v5 ad=2.175 pd=15.29 as=2.175 ps=15.29 w=15 l=0.5
X3 a_n1372_n1500# a_n1946_n1597# a_n1530_n1500# w_n2204_n1797# sky130_fd_pr__pfet_g5v0d10v5 ad=2.175 pd=15.29 as=2.175 ps=15.29 w=15 l=0.5
X4 a_998_n1500# a_n1946_n1597# a_840_n1500# w_n2204_n1797# sky130_fd_pr__pfet_g5v0d10v5 ad=2.175 pd=15.29 as=2.175 ps=15.29 w=15 l=0.5
X5 a_n108_n1500# a_n1946_n1597# a_n266_n1500# w_n2204_n1797# sky130_fd_pr__pfet_g5v0d10v5 ad=2.175 pd=15.29 as=2.175 ps=15.29 w=15 l=0.5
X6 a_1630_n1500# a_n1946_n1597# a_1472_n1500# w_n2204_n1797# sky130_fd_pr__pfet_g5v0d10v5 ad=2.175 pd=15.29 as=2.175 ps=15.29 w=15 l=0.5
X7 a_n266_n1500# a_n1946_n1597# a_n424_n1500# w_n2204_n1797# sky130_fd_pr__pfet_g5v0d10v5 ad=2.175 pd=15.29 as=2.175 ps=15.29 w=15 l=0.5
X8 a_n1846_n1500# a_n1946_n1597# a_n2004_n1500# w_n2204_n1797# sky130_fd_pr__pfet_g5v0d10v5 ad=2.175 pd=15.29 as=4.35 ps=30.58 w=15 l=0.5
X9 a_n740_n1500# a_n1946_n1597# a_n898_n1500# w_n2204_n1797# sky130_fd_pr__pfet_g5v0d10v5 ad=2.175 pd=15.29 as=2.175 ps=15.29 w=15 l=0.5
X10 a_n898_n1500# a_n1946_n1597# a_n1056_n1500# w_n2204_n1797# sky130_fd_pr__pfet_g5v0d10v5 ad=2.175 pd=15.29 as=2.175 ps=15.29 w=15 l=0.5
X11 a_1156_n1500# a_n1946_n1597# a_998_n1500# w_n2204_n1797# sky130_fd_pr__pfet_g5v0d10v5 ad=2.175 pd=15.29 as=2.175 ps=15.29 w=15 l=0.5
X12 a_524_n1500# a_n1946_n1597# a_366_n1500# w_n2204_n1797# sky130_fd_pr__pfet_g5v0d10v5 ad=2.175 pd=15.29 as=2.175 ps=15.29 w=15 l=0.5
X13 a_682_n1500# a_n1946_n1597# a_524_n1500# w_n2204_n1797# sky130_fd_pr__pfet_g5v0d10v5 ad=2.175 pd=15.29 as=2.175 ps=15.29 w=15 l=0.5
X14 a_1788_n1500# a_n1946_n1597# a_1630_n1500# w_n2204_n1797# sky130_fd_pr__pfet_g5v0d10v5 ad=2.175 pd=15.29 as=2.175 ps=15.29 w=15 l=0.5
X15 a_n424_n1500# a_n1946_n1597# a_n582_n1500# w_n2204_n1797# sky130_fd_pr__pfet_g5v0d10v5 ad=2.175 pd=15.29 as=2.175 ps=15.29 w=15 l=0.5
X16 a_n582_n1500# a_n1946_n1597# a_n740_n1500# w_n2204_n1797# sky130_fd_pr__pfet_g5v0d10v5 ad=2.175 pd=15.29 as=2.175 ps=15.29 w=15 l=0.5
X17 a_n1056_n1500# a_n1946_n1597# a_n1214_n1500# w_n2204_n1797# sky130_fd_pr__pfet_g5v0d10v5 ad=2.175 pd=15.29 as=2.175 ps=15.29 w=15 l=0.5
X18 a_1314_n1500# a_n1946_n1597# a_1156_n1500# w_n2204_n1797# sky130_fd_pr__pfet_g5v0d10v5 ad=2.175 pd=15.29 as=2.175 ps=15.29 w=15 l=0.5
X19 a_1472_n1500# a_n1946_n1597# a_1314_n1500# w_n2204_n1797# sky130_fd_pr__pfet_g5v0d10v5 ad=2.175 pd=15.29 as=2.175 ps=15.29 w=15 l=0.5
X20 a_n1530_n1500# a_n1946_n1597# a_n1688_n1500# w_n2204_n1797# sky130_fd_pr__pfet_g5v0d10v5 ad=2.175 pd=15.29 as=2.175 ps=15.29 w=15 l=0.5
X21 a_n1688_n1500# a_n1946_n1597# a_n1846_n1500# w_n2204_n1797# sky130_fd_pr__pfet_g5v0d10v5 ad=2.175 pd=15.29 as=2.175 ps=15.29 w=15 l=0.5
X22 a_840_n1500# a_n1946_n1597# a_682_n1500# w_n2204_n1797# sky130_fd_pr__pfet_g5v0d10v5 ad=2.175 pd=15.29 as=2.175 ps=15.29 w=15 l=0.5
X23 a_1946_n1500# a_n1946_n1597# a_1788_n1500# w_n2204_n1797# sky130_fd_pr__pfet_g5v0d10v5 ad=4.35 pd=30.58 as=2.175 ps=15.29 w=15 l=0.5
X24 a_208_n1500# a_n1946_n1597# a_50_n1500# w_n2204_n1797# sky130_fd_pr__pfet_g5v0d10v5 ad=2.175 pd=15.29 as=2.175 ps=15.29 w=15 l=0.5
.ends

.subckt m27 G w_44942_6212# D S
Xsky130_fd_pr__pfet_g5v0d10v5_UMEKA9_0 D S S D D S S D w_44942_6212# D S S D D S S
+ D D S S D D S D S D G S sky130_fd_pr__pfet_g5v0d10v5_UMEKA9
.ends

.subckt sky130_fd_pr__nfet_g5v0d10v5_GGFFNU B D S G
X0 S G D B sky130_fd_pr__nfet_g5v0d10v5 ad=1.45 pd=10.58 as=1.45 ps=10.58 w=5 l=8
.ends

.subckt sky130_fd_pr__nfet_g5v0d10v5_CMNTPV a_n266_n500# a_n560_n722# a_n424_n500#
X0 a_n424_n500# a_n424_n500# a_n266_n500# a_n560_n722# sky130_fd_pr__nfet_g5v0d10v5 ad=0.725 pd=5.29 as=0.725 ps=5.29 w=5 l=0.5
X1 a_n424_n500# a_n424_n500# a_n266_n500# a_n560_n722# sky130_fd_pr__nfet_g5v0d10v5 ad=0.725 pd=5.29 as=0.725 ps=5.29 w=5 l=0.5
X2 a_n266_n500# a_n424_n500# a_n424_n500# a_n560_n722# sky130_fd_pr__nfet_g5v0d10v5 ad=0.725 pd=5.29 as=1.45 ps=10.58 w=5 l=0.5
X3 a_n266_n500# a_n424_n500# a_n424_n500# a_n560_n722# sky130_fd_pr__nfet_g5v0d10v5 ad=1.45 pd=10.58 as=0.725 ps=5.29 w=5 l=0.5
X4 a_n266_n500# a_n424_n500# a_n424_n500# a_n560_n722# sky130_fd_pr__nfet_g5v0d10v5 ad=0.725 pd=5.29 as=0.725 ps=5.29 w=5 l=0.5
.ends

.subckt m25_26 D S
Xsky130_fd_pr__nfet_g5v0d10v5_CMNTPV_0 S S m1_160_1028# sky130_fd_pr__nfet_g5v0d10v5_CMNTPV
Xsky130_fd_pr__nfet_g5v0d10v5_CMNTPV_1 m1_160_1028# S D sky130_fd_pr__nfet_g5v0d10v5_CMNTPV
.ends

.subckt sky130_fd_pr__nfet_g5v0d10v5_R9FRNM a_n366_n1088# a_n424_n1000# a_n266_n1000#
+ a_n560_n1222#
X0 a_n266_n1000# a_n366_n1088# a_n424_n1000# a_n560_n1222# sky130_fd_pr__nfet_g5v0d10v5 ad=1.45 pd=10.29 as=2.9 ps=20.58 w=10 l=0.5
X1 a_n266_n1000# a_n366_n1088# a_n424_n1000# a_n560_n1222# sky130_fd_pr__nfet_g5v0d10v5 ad=2.9 pd=20.58 as=1.45 ps=10.29 w=10 l=0.5
X2 a_n266_n1000# a_n366_n1088# a_n424_n1000# a_n560_n1222# sky130_fd_pr__nfet_g5v0d10v5 ad=1.45 pd=10.29 as=1.45 ps=10.29 w=10 l=0.5
X3 a_n424_n1000# a_n366_n1088# a_n266_n1000# a_n560_n1222# sky130_fd_pr__nfet_g5v0d10v5 ad=1.45 pd=10.29 as=1.45 ps=10.29 w=10 l=0.5
X4 a_n424_n1000# a_n366_n1088# a_n266_n1000# a_n560_n1222# sky130_fd_pr__nfet_g5v0d10v5 ad=1.45 pd=10.29 as=1.45 ps=10.29 w=10 l=0.5
.ends

.subckt m23 sky130_fd_pr__nfet_g5v0d10v5_R9FRNM_0/a_n366_n1088# sky130_fd_pr__nfet_g5v0d10v5_R9FRNM_0/a_n424_n1000#
+ sky130_fd_pr__nfet_g5v0d10v5_R9FRNM_0/a_n266_n1000# VSUBS
Xsky130_fd_pr__nfet_g5v0d10v5_R9FRNM_0 sky130_fd_pr__nfet_g5v0d10v5_R9FRNM_0/a_n366_n1088#
+ sky130_fd_pr__nfet_g5v0d10v5_R9FRNM_0/a_n424_n1000# sky130_fd_pr__nfet_g5v0d10v5_R9FRNM_0/a_n266_n1000#
+ VSUBS sky130_fd_pr__nfet_g5v0d10v5_R9FRNM
.ends

.subckt sky130_fd_pr__cap_mim_m3_1_ZUZAFU C2_0_0 C1_0_0 C2_0_1 C1_0_1 C2_1_0 C1_1_0
+ C2_1_1 C1_1_1
X0 C1_1_0 C2_1_0 sky130_fd_pr__cap_mim_m3_1 l=20 w=30
X1 C1_0_1 C2_0_1 sky130_fd_pr__cap_mim_m3_1 l=20 w=30
X2 C1_0_0 C2_0_0 sky130_fd_pr__cap_mim_m3_1 l=20 w=30
X3 C1_1_1 C2_1_1 sky130_fd_pr__cap_mim_m3_1 l=20 w=30
.ends

.subckt c1 M4 M3
Xsky130_fd_pr__cap_mim_m3_1_ZUZAFU_0 M3 M4 M3 M4 M3 M4 M3 M4 sky130_fd_pr__cap_mim_m3_1_ZUZAFU
.ends

.subckt sky130_fd_pr__nfet_g5v0d10v5_H9RT8X a_682_n1000# a_n1156_n1088# a_n108_n1000#
+ a_n1214_n1000# a_998_n1000# a_n1056_n1000# a_n424_n1000# a_n266_n1000# a_n740_n1000#
+ a_n582_n1000# a_n898_n1000# a_50_n1000# a_n1350_n1222# a_208_n1000# a_524_n1000#
+ a_1156_n1000# a_366_n1000# a_840_n1000#
X0 a_682_n1000# a_n1156_n1088# a_524_n1000# a_n1350_n1222# sky130_fd_pr__nfet_g5v0d10v5 ad=1.45 pd=10.29 as=1.45 ps=10.29 w=10 l=0.5
X1 a_n266_n1000# a_n1156_n1088# a_n424_n1000# a_n1350_n1222# sky130_fd_pr__nfet_g5v0d10v5 ad=1.45 pd=10.29 as=1.45 ps=10.29 w=10 l=0.5
X2 a_840_n1000# a_n1156_n1088# a_682_n1000# a_n1350_n1222# sky130_fd_pr__nfet_g5v0d10v5 ad=1.45 pd=10.29 as=1.45 ps=10.29 w=10 l=0.5
X3 a_366_n1000# a_n1156_n1088# a_208_n1000# a_n1350_n1222# sky130_fd_pr__nfet_g5v0d10v5 ad=1.45 pd=10.29 as=1.45 ps=10.29 w=10 l=0.5
X4 a_n898_n1000# a_n1156_n1088# a_n1056_n1000# a_n1350_n1222# sky130_fd_pr__nfet_g5v0d10v5 ad=1.45 pd=10.29 as=1.45 ps=10.29 w=10 l=0.5
X5 a_50_n1000# a_n1156_n1088# a_n108_n1000# a_n1350_n1222# sky130_fd_pr__nfet_g5v0d10v5 ad=1.45 pd=10.29 as=1.45 ps=10.29 w=10 l=0.5
X6 a_n424_n1000# a_n1156_n1088# a_n582_n1000# a_n1350_n1222# sky130_fd_pr__nfet_g5v0d10v5 ad=1.45 pd=10.29 as=1.45 ps=10.29 w=10 l=0.5
X7 a_998_n1000# a_n1156_n1088# a_840_n1000# a_n1350_n1222# sky130_fd_pr__nfet_g5v0d10v5 ad=1.45 pd=10.29 as=1.45 ps=10.29 w=10 l=0.5
X8 a_524_n1000# a_n1156_n1088# a_366_n1000# a_n1350_n1222# sky130_fd_pr__nfet_g5v0d10v5 ad=1.45 pd=10.29 as=1.45 ps=10.29 w=10 l=0.5
X9 a_n1056_n1000# a_n1156_n1088# a_n1214_n1000# a_n1350_n1222# sky130_fd_pr__nfet_g5v0d10v5 ad=1.45 pd=10.29 as=2.9 ps=20.58 w=10 l=0.5
X10 a_1156_n1000# a_n1156_n1088# a_998_n1000# a_n1350_n1222# sky130_fd_pr__nfet_g5v0d10v5 ad=2.9 pd=20.58 as=1.45 ps=10.29 w=10 l=0.5
X11 a_n108_n1000# a_n1156_n1088# a_n266_n1000# a_n1350_n1222# sky130_fd_pr__nfet_g5v0d10v5 ad=1.45 pd=10.29 as=1.45 ps=10.29 w=10 l=0.5
X12 a_208_n1000# a_n1156_n1088# a_50_n1000# a_n1350_n1222# sky130_fd_pr__nfet_g5v0d10v5 ad=1.45 pd=10.29 as=1.45 ps=10.29 w=10 l=0.5
X13 a_n740_n1000# a_n1156_n1088# a_n898_n1000# a_n1350_n1222# sky130_fd_pr__nfet_g5v0d10v5 ad=1.45 pd=10.29 as=1.45 ps=10.29 w=10 l=0.5
X14 a_n582_n1000# a_n1156_n1088# a_n740_n1000# a_n1350_n1222# sky130_fd_pr__nfet_g5v0d10v5 ad=1.45 pd=10.29 as=1.45 ps=10.29 w=10 l=0.5
.ends

.subckt m28 G D S VSUBS
Xsky130_fd_pr__nfet_g5v0d10v5_H9RT8X_0 D G S D D S S D S D D D VSUBS S S S D S sky130_fd_pr__nfet_g5v0d10v5_H9RT8X
.ends

.subckt sky130_fd_pr__nfet_g5v0d10v5_XH6BGL a_n1776_n1333# a_n1282_n1111# a_n1582_n1199#
+ a_n1640_n1111#
X0 a_n1282_n1111# a_n1582_n1199# a_n1640_n1111# a_n1776_n1333# sky130_fd_pr__nfet_g5v0d10v5 ad=1.61095 pd=11.4 as=1.61095 ps=11.4 w=11.11 l=1.5
X1 a_n1282_n1111# a_n1582_n1199# a_n1640_n1111# a_n1776_n1333# sky130_fd_pr__nfet_g5v0d10v5 ad=1.61095 pd=11.4 as=1.61095 ps=11.4 w=11.11 l=1.5
X2 a_n1282_n1111# a_n1582_n1199# a_n1640_n1111# a_n1776_n1333# sky130_fd_pr__nfet_g5v0d10v5 ad=1.61095 pd=11.4 as=3.2219 ps=22.8 w=11.11 l=1.5
X3 a_n1640_n1111# a_n1582_n1199# a_n1282_n1111# a_n1776_n1333# sky130_fd_pr__nfet_g5v0d10v5 ad=1.61095 pd=11.4 as=1.61095 ps=11.4 w=11.11 l=1.5
X4 a_n1640_n1111# a_n1582_n1199# a_n1282_n1111# a_n1776_n1333# sky130_fd_pr__nfet_g5v0d10v5 ad=1.61095 pd=11.4 as=1.61095 ps=11.4 w=11.11 l=1.5
X5 a_n1640_n1111# a_n1582_n1199# a_n1282_n1111# a_n1776_n1333# sky130_fd_pr__nfet_g5v0d10v5 ad=1.61095 pd=11.4 as=1.61095 ps=11.4 w=11.11 l=1.5
X6 a_n1640_n1111# a_n1582_n1199# a_n1282_n1111# a_n1776_n1333# sky130_fd_pr__nfet_g5v0d10v5 ad=1.61095 pd=11.4 as=1.61095 ps=11.4 w=11.11 l=1.5
X7 a_n1282_n1111# a_n1582_n1199# a_n1640_n1111# a_n1776_n1333# sky130_fd_pr__nfet_g5v0d10v5 ad=3.2219 pd=22.8 as=1.61095 ps=11.4 w=11.11 l=1.5
X8 a_n1282_n1111# a_n1582_n1199# a_n1640_n1111# a_n1776_n1333# sky130_fd_pr__nfet_g5v0d10v5 ad=1.61095 pd=11.4 as=1.61095 ps=11.4 w=11.11 l=1.5
.ends

.subckt m29_30 D30 G29 S G30 D29 VSUBS
Xsky130_fd_pr__nfet_g5v0d10v5_XH6BGL_0 VSUBS S G29 D29 sky130_fd_pr__nfet_g5v0d10v5_XH6BGL
Xsky130_fd_pr__nfet_g5v0d10v5_XH6BGL_1 VSUBS S G30 D30 sky130_fd_pr__nfet_g5v0d10v5_XH6BGL
.ends

.subckt sky130_fd_pr__pfet_g5v0d10v5_DY6QAT a_n424_n1500# a_n266_n1500# w_n624_n1797#
X0 a_n266_n1500# a_n424_n1500# a_n424_n1500# w_n624_n1797# sky130_fd_pr__pfet_g5v0d10v5 ad=4.35 pd=30.58 as=2.175 ps=15.29 w=15 l=0.5
X1 a_n266_n1500# a_n424_n1500# a_n424_n1500# w_n624_n1797# sky130_fd_pr__pfet_g5v0d10v5 ad=2.175 pd=15.29 as=2.175 ps=15.29 w=15 l=0.5
X2 a_n424_n1500# a_n424_n1500# a_n266_n1500# w_n624_n1797# sky130_fd_pr__pfet_g5v0d10v5 ad=2.175 pd=15.29 as=2.175 ps=15.29 w=15 l=0.5
X3 a_n266_n1500# a_n424_n1500# a_n424_n1500# w_n624_n1797# sky130_fd_pr__pfet_g5v0d10v5 ad=2.175 pd=15.29 as=4.35 ps=30.58 w=15 l=0.5
X4 a_n424_n1500# a_n424_n1500# a_n266_n1500# w_n624_n1797# sky130_fd_pr__pfet_g5v0d10v5 ad=2.175 pd=15.29 as=2.175 ps=15.29 w=15 l=0.5
.ends

.subckt m21_22 D S
Xsky130_fd_pr__pfet_g5v0d10v5_DY6QAT_0 G S S sky130_fd_pr__pfet_g5v0d10v5_DY6QAT
Xsky130_fd_pr__pfet_g5v0d10v5_DY6QAT_1 D G S sky130_fd_pr__pfet_g5v0d10v5_DY6QAT
.ends

.subckt sky130_fd_pr__pfet_g5v0d10v5_J3544R a_n1214_n1000# a_n1056_n1000# a_n1156_n1097#
+ w_n1414_n1297#
X0 a_n1214_n1000# a_n1156_n1097# a_n1056_n1000# w_n1414_n1297# sky130_fd_pr__pfet_g5v0d10v5 ad=1.45 pd=10.29 as=1.45 ps=10.29 w=10 l=0.5
X1 a_n1214_n1000# a_n1156_n1097# a_n1056_n1000# w_n1414_n1297# sky130_fd_pr__pfet_g5v0d10v5 ad=1.45 pd=10.29 as=1.45 ps=10.29 w=10 l=0.5
X2 a_n1214_n1000# a_n1156_n1097# a_n1056_n1000# w_n1414_n1297# sky130_fd_pr__pfet_g5v0d10v5 ad=1.45 pd=10.29 as=1.45 ps=10.29 w=10 l=0.5
X3 a_n1056_n1000# a_n1156_n1097# a_n1214_n1000# w_n1414_n1297# sky130_fd_pr__pfet_g5v0d10v5 ad=1.45 pd=10.29 as=1.45 ps=10.29 w=10 l=0.5
X4 a_n1214_n1000# a_n1156_n1097# a_n1056_n1000# w_n1414_n1297# sky130_fd_pr__pfet_g5v0d10v5 ad=1.45 pd=10.29 as=1.45 ps=10.29 w=10 l=0.5
X5 a_n1214_n1000# a_n1156_n1097# a_n1056_n1000# w_n1414_n1297# sky130_fd_pr__pfet_g5v0d10v5 ad=1.45 pd=10.29 as=1.45 ps=10.29 w=10 l=0.5
X6 a_n1214_n1000# a_n1156_n1097# a_n1056_n1000# w_n1414_n1297# sky130_fd_pr__pfet_g5v0d10v5 ad=1.45 pd=10.29 as=1.45 ps=10.29 w=10 l=0.5
X7 a_n1056_n1000# a_n1156_n1097# a_n1214_n1000# w_n1414_n1297# sky130_fd_pr__pfet_g5v0d10v5 ad=1.45 pd=10.29 as=1.45 ps=10.29 w=10 l=0.5
X8 a_n1214_n1000# a_n1156_n1097# a_n1056_n1000# w_n1414_n1297# sky130_fd_pr__pfet_g5v0d10v5 ad=1.45 pd=10.29 as=1.45 ps=10.29 w=10 l=0.5
X9 a_n1056_n1000# a_n1156_n1097# a_n1214_n1000# w_n1414_n1297# sky130_fd_pr__pfet_g5v0d10v5 ad=1.45 pd=10.29 as=1.45 ps=10.29 w=10 l=0.5
X10 a_n1056_n1000# a_n1156_n1097# a_n1214_n1000# w_n1414_n1297# sky130_fd_pr__pfet_g5v0d10v5 ad=1.45 pd=10.29 as=2.9 ps=20.58 w=10 l=0.5
X11 a_n1056_n1000# a_n1156_n1097# a_n1214_n1000# w_n1414_n1297# sky130_fd_pr__pfet_g5v0d10v5 ad=2.9 pd=20.58 as=1.45 ps=10.29 w=10 l=0.5
X12 a_n1056_n1000# a_n1156_n1097# a_n1214_n1000# w_n1414_n1297# sky130_fd_pr__pfet_g5v0d10v5 ad=1.45 pd=10.29 as=1.45 ps=10.29 w=10 l=0.5
X13 a_n1056_n1000# a_n1156_n1097# a_n1214_n1000# w_n1414_n1297# sky130_fd_pr__pfet_g5v0d10v5 ad=1.45 pd=10.29 as=1.45 ps=10.29 w=10 l=0.5
X14 a_n1056_n1000# a_n1156_n1097# a_n1214_n1000# w_n1414_n1297# sky130_fd_pr__pfet_g5v0d10v5 ad=1.45 pd=10.29 as=1.45 ps=10.29 w=10 l=0.5
.ends

.subckt m19 sky130_fd_pr__pfet_g5v0d10v5_J3544R_0/w_n1414_n1297# sky130_fd_pr__pfet_g5v0d10v5_J3544R_0/a_n1214_n1000#
+ sky130_fd_pr__pfet_g5v0d10v5_J3544R_0/a_n1056_n1000# sky130_fd_pr__pfet_g5v0d10v5_J3544R_0/a_n1156_n1097#
Xsky130_fd_pr__pfet_g5v0d10v5_J3544R_0 sky130_fd_pr__pfet_g5v0d10v5_J3544R_0/a_n1214_n1000#
+ sky130_fd_pr__pfet_g5v0d10v5_J3544R_0/a_n1056_n1000# sky130_fd_pr__pfet_g5v0d10v5_J3544R_0/a_n1156_n1097#
+ sky130_fd_pr__pfet_g5v0d10v5_J3544R_0/w_n1414_n1297# sky130_fd_pr__pfet_g5v0d10v5_J3544R
.ends

.subckt sky130_fd_pr__pfet_g5v0d10v5_DB8A6Y a_n500_n597# w_n1816_n797# a_1558_n500#
+ a_500_n500# a_n558_n500# a_558_n597# a_n1616_n500# a_n1558_n597#
X0 a_1558_n500# a_558_n597# a_500_n500# w_n1816_n797# sky130_fd_pr__pfet_g5v0d10v5 ad=1.45 pd=10.58 as=0.725 ps=5.29 w=5 l=5
X1 a_500_n500# a_n500_n597# a_n558_n500# w_n1816_n797# sky130_fd_pr__pfet_g5v0d10v5 ad=0.725 pd=5.29 as=0.725 ps=5.29 w=5 l=5
X2 a_n558_n500# a_n1558_n597# a_n1616_n500# w_n1816_n797# sky130_fd_pr__pfet_g5v0d10v5 ad=0.725 pd=5.29 as=1.45 ps=10.58 w=5 l=5
.ends

.subckt sky130_fd_pr__pfet_g5v0d10v5_PUA7NM a_258_n757# a_200_n660# a_n716_n660# a_n200_n757#
+ a_n258_n660# w_n916_n957# a_658_n660# a_n658_n757#
X0 a_200_n660# a_n200_n757# a_n258_n660# w_n916_n957# sky130_fd_pr__pfet_g5v0d10v5 ad=0.957 pd=6.89 as=0.957 ps=6.89 w=6.6 l=2
X1 a_658_n660# a_258_n757# a_200_n660# w_n916_n957# sky130_fd_pr__pfet_g5v0d10v5 ad=1.914 pd=13.78 as=0.957 ps=6.89 w=6.6 l=2
X2 a_n258_n660# a_n658_n757# a_n716_n660# w_n916_n957# sky130_fd_pr__pfet_g5v0d10v5 ad=0.957 pd=6.89 as=1.914 ps=13.78 w=6.6 l=2
.ends

.subckt m5_m6 G D S
Xsky130_fd_pr__pfet_g5v0d10v5_DB8A6Y_0 G S m1_4014_7500# S m1_4014_7500# G S G sky130_fd_pr__pfet_g5v0d10v5_DB8A6Y
Xsky130_fd_pr__pfet_g5v0d10v5_PUA7NM_0 G m1_4014_7500# m1_4014_7500# G D S D G sky130_fd_pr__pfet_g5v0d10v5_PUA7NM
.ends

.subckt opamp Vref Vp Vn VDD Vg1 Vout GND
Xm13_14 Vg11 Vg27 VDD Vd29 m11_12
XM20 GND Vg22 GND Vg1 sky130_fd_pr__nfet_g5v0d10v5_VXNDUF
XM24 VDD VDD Vd24 Vg5 sky130_fd_pr__pfet_g5v0d10v5_4KCRW8
Xm07_08_0 Vg5 Vd8 VDD m07_08
Xm15_16_0 Vg11 Vd10 Vg1 GND m15_16
Xm31_32_0 Vs29 Vg1 GND m31_32
Xm09_10_0 Vd10 Vd9 Vp Vn Vd8 m09_10
XM03_04 Vg1 Vg5 GND m01_02
Xm27_0 Vg27 VDD Vout VDD m27
XMr1 GND VgR2 GND Vref sky130_fd_pr__nfet_g5v0d10v5_GGFFNU
XMr2 VDD VDD VgR2 VgR2 sky130_fd_pr__pfet_g5v0d10v5_4KCRW8
XMr3 VDD VDD Vg1 VgR2 sky130_fd_pr__pfet_g5v0d10v5_4KCRW8
XM17_18 Vg28 Vd9 Vg1 GND m15_16
Xm25_26_0 Vd24 GND m25_26
Xm23_0 Vd24 Vg27 Vg28 GND m23
Xm11_12_0 Vg11 Vg11 VDD Vd30 m11_12
Xc1 Vg27 Vout c1
Xc2 Vg28 Vout c1
Xm01_02 Vg1 Vg1 GND m01_02
Xm28_0 Vg28 Vout GND GND m28
Xm29_30_0 Vd30 Vp Vs29 Vn Vd29 GND m29_30
Xm21_22_0 Vg22 VDD m21_22
Xm19_0 VDD Vg27 Vg28 Vg22 m19
Xm5_m6_0 Vg5 Vg5 VDD m5_m6
.ends

.subckt sky130_fd_pr__nfet_g5v0d10v5_4GJ86D a_n1058_109# a_n1058_427# a_n1058_745#
+ a_n1000_n297# a_1000_n1481# a_1000_n1163# a_n1000_1293# a_n1000_n615# a_n1000_339#
+ a_n1000_657# a_n1194_n1703# a_n1000_n933# a_n1000_975# a_n1000_n1569# a_1000_109#
+ a_1000_427# a_1000_745# a_n1058_n1481# a_n1058_n1163# a_1000_n209# a_1000_n845#
+ a_1000_n527# a_n1058_n209# a_n1058_n845# a_n1058_n527# a_1000_1063# a_n1058_1063#
+ a_1000_1381# a_n1058_1381# a_n1000_n1251# a_n1000_21#
X0 a_1000_427# a_n1000_339# a_n1058_427# a_n1194_n1703# sky130_fd_pr__nfet_g5v0d10v5 ad=0.145 pd=1.58 as=0.145 ps=1.58 w=0.5 l=10
X1 a_1000_n845# a_n1000_n933# a_n1058_n845# a_n1194_n1703# sky130_fd_pr__nfet_g5v0d10v5 ad=0.145 pd=1.58 as=0.145 ps=1.58 w=0.5 l=10
X2 a_1000_n1163# a_n1000_n1251# a_n1058_n1163# a_n1194_n1703# sky130_fd_pr__nfet_g5v0d10v5 ad=0.145 pd=1.58 as=0.145 ps=1.58 w=0.5 l=10
X3 a_1000_1381# a_n1000_1293# a_n1058_1381# a_n1194_n1703# sky130_fd_pr__nfet_g5v0d10v5 ad=0.145 pd=1.58 as=0.145 ps=1.58 w=0.5 l=10
X4 a_1000_109# a_n1000_21# a_n1058_109# a_n1194_n1703# sky130_fd_pr__nfet_g5v0d10v5 ad=0.145 pd=1.58 as=0.145 ps=1.58 w=0.5 l=10
X5 a_1000_n527# a_n1000_n615# a_n1058_n527# a_n1194_n1703# sky130_fd_pr__nfet_g5v0d10v5 ad=0.145 pd=1.58 as=0.145 ps=1.58 w=0.5 l=10
X6 a_1000_1063# a_n1000_975# a_n1058_1063# a_n1194_n1703# sky130_fd_pr__nfet_g5v0d10v5 ad=0.145 pd=1.58 as=0.145 ps=1.58 w=0.5 l=10
X7 a_1000_n209# a_n1000_n297# a_n1058_n209# a_n1194_n1703# sky130_fd_pr__nfet_g5v0d10v5 ad=0.145 pd=1.58 as=0.145 ps=1.58 w=0.5 l=10
X8 a_1000_745# a_n1000_657# a_n1058_745# a_n1194_n1703# sky130_fd_pr__nfet_g5v0d10v5 ad=0.145 pd=1.58 as=0.145 ps=1.58 w=0.5 l=10
X9 a_1000_n1481# a_n1000_n1569# a_n1058_n1481# a_n1194_n1703# sky130_fd_pr__nfet_g5v0d10v5 ad=0.145 pd=1.58 as=0.145 ps=1.58 w=0.5 l=10
.ends

.subckt bandgap_m7 D S G VSUBS
Xsky130_fd_pr__nfet_g5v0d10v5_4GJ86D_0 li_n4361_404# li_n4358_1040# li_n4358_1040#
+ G S li_n2243_n546# G G G G VSUBS G G G li_n2243_728# li_n2243_728# li_n2244_1360#
+ li_n4362_n868# li_n4362_n868# li_n2244_88# li_n2243_n546# li_n2244_88# li_n4361_404#
+ li_n4360_n232# li_n4360_n232# li_n2244_1360# li_n4363_1674# D li_n4363_1674# G G
+ sky130_fd_pr__nfet_g5v0d10v5_4GJ86D
.ends

.subckt sky130_fd_pr__rf_pnp_05v5_W3p40L3p40 Emitter Collector Base m=1
X0 Collector Base Emitter sky130_fd_pr__pnp_05v5_W3p40L3p40
**devattr s=462400,2720
.ends

.subckt bandgap_bjts sky130_fd_pr__rf_pnp_05v5_W3p40L3p40_0[4|4]/Emitter sky130_fd_pr__rf_pnp_05v5_W3p40L3p40_0[2|2]/Emitter
+ VSUBS
Xsky130_fd_pr__rf_pnp_05v5_W3p40L3p40_0[0|0] sky130_fd_pr__rf_pnp_05v5_W3p40L3p40_0[4|4]/Emitter
+ VSUBS VSUBS sky130_fd_pr__rf_pnp_05v5_W3p40L3p40 m=1
Xsky130_fd_pr__rf_pnp_05v5_W3p40L3p40_0[1|0] sky130_fd_pr__rf_pnp_05v5_W3p40L3p40_0[4|4]/Emitter
+ VSUBS VSUBS sky130_fd_pr__rf_pnp_05v5_W3p40L3p40 m=1
Xsky130_fd_pr__rf_pnp_05v5_W3p40L3p40_0[2|0] sky130_fd_pr__rf_pnp_05v5_W3p40L3p40_0[4|4]/Emitter
+ VSUBS VSUBS sky130_fd_pr__rf_pnp_05v5_W3p40L3p40 m=1
Xsky130_fd_pr__rf_pnp_05v5_W3p40L3p40_0[3|0] sky130_fd_pr__rf_pnp_05v5_W3p40L3p40_0[4|4]/Emitter
+ VSUBS VSUBS sky130_fd_pr__rf_pnp_05v5_W3p40L3p40 m=1
Xsky130_fd_pr__rf_pnp_05v5_W3p40L3p40_0[4|0] sky130_fd_pr__rf_pnp_05v5_W3p40L3p40_0[4|4]/Emitter
+ VSUBS VSUBS sky130_fd_pr__rf_pnp_05v5_W3p40L3p40 m=1
Xsky130_fd_pr__rf_pnp_05v5_W3p40L3p40_0[0|1] sky130_fd_pr__rf_pnp_05v5_W3p40L3p40_0[4|4]/Emitter
+ VSUBS VSUBS sky130_fd_pr__rf_pnp_05v5_W3p40L3p40 m=1
Xsky130_fd_pr__rf_pnp_05v5_W3p40L3p40_0[1|1] sky130_fd_pr__rf_pnp_05v5_W3p40L3p40_0[4|4]/Emitter
+ VSUBS VSUBS sky130_fd_pr__rf_pnp_05v5_W3p40L3p40 m=1
Xsky130_fd_pr__rf_pnp_05v5_W3p40L3p40_0[2|1] sky130_fd_pr__rf_pnp_05v5_W3p40L3p40_0[4|4]/Emitter
+ VSUBS VSUBS sky130_fd_pr__rf_pnp_05v5_W3p40L3p40 m=1
Xsky130_fd_pr__rf_pnp_05v5_W3p40L3p40_0[3|1] sky130_fd_pr__rf_pnp_05v5_W3p40L3p40_0[4|4]/Emitter
+ VSUBS VSUBS sky130_fd_pr__rf_pnp_05v5_W3p40L3p40 m=1
Xsky130_fd_pr__rf_pnp_05v5_W3p40L3p40_0[4|1] sky130_fd_pr__rf_pnp_05v5_W3p40L3p40_0[4|4]/Emitter
+ VSUBS VSUBS sky130_fd_pr__rf_pnp_05v5_W3p40L3p40 m=1
Xsky130_fd_pr__rf_pnp_05v5_W3p40L3p40_0[0|2] sky130_fd_pr__rf_pnp_05v5_W3p40L3p40_0[4|4]/Emitter
+ VSUBS VSUBS sky130_fd_pr__rf_pnp_05v5_W3p40L3p40 m=1
Xsky130_fd_pr__rf_pnp_05v5_W3p40L3p40_0[1|2] sky130_fd_pr__rf_pnp_05v5_W3p40L3p40_0[4|4]/Emitter
+ VSUBS VSUBS sky130_fd_pr__rf_pnp_05v5_W3p40L3p40 m=1
Xsky130_fd_pr__rf_pnp_05v5_W3p40L3p40_0[2|2] sky130_fd_pr__rf_pnp_05v5_W3p40L3p40_0[2|2]/Emitter
+ VSUBS VSUBS sky130_fd_pr__rf_pnp_05v5_W3p40L3p40 m=1
Xsky130_fd_pr__rf_pnp_05v5_W3p40L3p40_0[3|2] sky130_fd_pr__rf_pnp_05v5_W3p40L3p40_0[4|4]/Emitter
+ VSUBS VSUBS sky130_fd_pr__rf_pnp_05v5_W3p40L3p40 m=1
Xsky130_fd_pr__rf_pnp_05v5_W3p40L3p40_0[4|2] sky130_fd_pr__rf_pnp_05v5_W3p40L3p40_0[4|4]/Emitter
+ VSUBS VSUBS sky130_fd_pr__rf_pnp_05v5_W3p40L3p40 m=1
Xsky130_fd_pr__rf_pnp_05v5_W3p40L3p40_0[0|3] sky130_fd_pr__rf_pnp_05v5_W3p40L3p40_0[4|4]/Emitter
+ VSUBS VSUBS sky130_fd_pr__rf_pnp_05v5_W3p40L3p40 m=1
Xsky130_fd_pr__rf_pnp_05v5_W3p40L3p40_0[1|3] sky130_fd_pr__rf_pnp_05v5_W3p40L3p40_0[4|4]/Emitter
+ VSUBS VSUBS sky130_fd_pr__rf_pnp_05v5_W3p40L3p40 m=1
Xsky130_fd_pr__rf_pnp_05v5_W3p40L3p40_0[2|3] sky130_fd_pr__rf_pnp_05v5_W3p40L3p40_0[4|4]/Emitter
+ VSUBS VSUBS sky130_fd_pr__rf_pnp_05v5_W3p40L3p40 m=1
Xsky130_fd_pr__rf_pnp_05v5_W3p40L3p40_0[3|3] sky130_fd_pr__rf_pnp_05v5_W3p40L3p40_0[4|4]/Emitter
+ VSUBS VSUBS sky130_fd_pr__rf_pnp_05v5_W3p40L3p40 m=1
Xsky130_fd_pr__rf_pnp_05v5_W3p40L3p40_0[4|3] sky130_fd_pr__rf_pnp_05v5_W3p40L3p40_0[4|4]/Emitter
+ VSUBS VSUBS sky130_fd_pr__rf_pnp_05v5_W3p40L3p40 m=1
Xsky130_fd_pr__rf_pnp_05v5_W3p40L3p40_0[0|4] sky130_fd_pr__rf_pnp_05v5_W3p40L3p40_0[4|4]/Emitter
+ VSUBS VSUBS sky130_fd_pr__rf_pnp_05v5_W3p40L3p40 m=1
Xsky130_fd_pr__rf_pnp_05v5_W3p40L3p40_0[1|4] sky130_fd_pr__rf_pnp_05v5_W3p40L3p40_0[4|4]/Emitter
+ VSUBS VSUBS sky130_fd_pr__rf_pnp_05v5_W3p40L3p40 m=1
Xsky130_fd_pr__rf_pnp_05v5_W3p40L3p40_0[2|4] sky130_fd_pr__rf_pnp_05v5_W3p40L3p40_0[4|4]/Emitter
+ VSUBS VSUBS sky130_fd_pr__rf_pnp_05v5_W3p40L3p40 m=1
Xsky130_fd_pr__rf_pnp_05v5_W3p40L3p40_0[3|4] sky130_fd_pr__rf_pnp_05v5_W3p40L3p40_0[4|4]/Emitter
+ VSUBS VSUBS sky130_fd_pr__rf_pnp_05v5_W3p40L3p40 m=1
Xsky130_fd_pr__rf_pnp_05v5_W3p40L3p40_0[4|4] sky130_fd_pr__rf_pnp_05v5_W3p40L3p40_0[4|4]/Emitter
+ VSUBS VSUBS sky130_fd_pr__rf_pnp_05v5_W3p40L3p40 m=1
.ends

.subckt sky130_fd_pr__nfet_g5v0d10v5_SNXN39 B D0 G0 S1 G1 D2 G2 S3 G3 D4 S4 G4
X0 S4 G4 D4 B sky130_fd_pr__nfet_g5v0d10v5 ad=1.16 pd=8.58 as=0.58 ps=4.29 w=4 l=1
X1 D4 G3 S3 B sky130_fd_pr__nfet_g5v0d10v5 ad=0.58 pd=4.29 as=0.58 ps=4.29 w=4 l=1
X2 S3 G2 D2 B sky130_fd_pr__nfet_g5v0d10v5 ad=0.58 pd=4.29 as=0.58 ps=4.29 w=4 l=1
X3 S1 G0 D0 B sky130_fd_pr__nfet_g5v0d10v5 ad=0.58 pd=4.29 as=1.16 ps=8.58 w=4 l=1
X4 D2 G1 S1 B sky130_fd_pr__nfet_g5v0d10v5 ad=0.58 pd=4.29 as=0.58 ps=4.29 w=4 l=1
.ends

.subckt bandgap_m3 S D G VSUBS
Xsky130_fd_pr__nfet_g5v0d10v5_SNXN39_0 VSUBS S G D G S G D G S D G sky130_fd_pr__nfet_g5v0d10v5_SNXN39
.ends

.subckt sky130_fd_pr__pfet_g5v0d10v5_P62BBU B D0 G0 S1 G1 D2 G2 S3 G3 D4 S4 G4
X0 S4 G4 D4 B sky130_fd_pr__pfet_g5v0d10v5 ad=1.16 pd=8.58 as=0.58 ps=4.29 w=4 l=1
X1 D4 G3 S3 B sky130_fd_pr__pfet_g5v0d10v5 ad=0.58 pd=4.29 as=0.58 ps=4.29 w=4 l=1
X2 S3 G2 D2 B sky130_fd_pr__pfet_g5v0d10v5 ad=0.58 pd=4.29 as=0.58 ps=4.29 w=4 l=1
X3 S1 G0 D0 B sky130_fd_pr__pfet_g5v0d10v5 ad=0.58 pd=4.29 as=1.16 ps=8.58 w=4 l=1
X4 D2 G1 S1 B sky130_fd_pr__pfet_g5v0d10v5 ad=0.58 pd=4.29 as=0.58 ps=4.29 w=4 l=1
.ends

.subckt bandgap_m1 sky130_fd_pr__pfet_g5v0d10v5_P62BBU_0/D4 sky130_fd_pr__pfet_g5v0d10v5_P62BBU_0/G4
+ sky130_fd_pr__pfet_g5v0d10v5_P62BBU_0/B sky130_fd_pr__pfet_g5v0d10v5_P62BBU_0/S4
Xsky130_fd_pr__pfet_g5v0d10v5_P62BBU_0 sky130_fd_pr__pfet_g5v0d10v5_P62BBU_0/B sky130_fd_pr__pfet_g5v0d10v5_P62BBU_0/D4
+ sky130_fd_pr__pfet_g5v0d10v5_P62BBU_0/G4 sky130_fd_pr__pfet_g5v0d10v5_P62BBU_0/S4
+ sky130_fd_pr__pfet_g5v0d10v5_P62BBU_0/G4 sky130_fd_pr__pfet_g5v0d10v5_P62BBU_0/D4
+ sky130_fd_pr__pfet_g5v0d10v5_P62BBU_0/G4 sky130_fd_pr__pfet_g5v0d10v5_P62BBU_0/S4
+ sky130_fd_pr__pfet_g5v0d10v5_P62BBU_0/G4 sky130_fd_pr__pfet_g5v0d10v5_P62BBU_0/D4
+ sky130_fd_pr__pfet_g5v0d10v5_P62BBU_0/S4 sky130_fd_pr__pfet_g5v0d10v5_P62BBU_0/G4
+ sky130_fd_pr__pfet_g5v0d10v5_P62BBU
.ends

.subckt sky130_fd_pr__nfet_g5v0d10v5_98BQ98 B D S G
X0 S G D B sky130_fd_pr__nfet_g5v0d10v5 ad=1.45 pd=10.58 as=1.45 ps=10.58 w=5 l=1
.ends

.subckt sky130_fd_pr__res_high_po_0p69_TK733K B R1 R2
X0 R2 R1 B sky130_fd_pr__res_high_po_0p69 l=6.99
.ends

.subckt sky130_fd_pr__pfet_g5v0d10v5_CEYAGG B D S G
X0 S G D B sky130_fd_pr__pfet_g5v0d10v5 ad=0.29 pd=2.58 as=0.29 ps=2.58 w=1 l=1
.ends

.subckt sky130_fd_pr__pfet_g5v0d10v5_DQLY7V B a_208_n400# a_n366_n497# a_366_n400#
+ a_50_n400# a_n108_n400# a_n266_n400# a_n424_n400#
X0 a_n266_n400# a_n366_n497# a_n424_n400# B sky130_fd_pr__pfet_g5v0d10v5 ad=0.58 pd=4.29 as=1.16 ps=8.58 w=4 l=0.5
X1 a_366_n400# a_n366_n497# a_208_n400# B sky130_fd_pr__pfet_g5v0d10v5 ad=1.16 pd=8.58 as=0.58 ps=4.29 w=4 l=0.5
X2 a_50_n400# a_n366_n497# a_n108_n400# B sky130_fd_pr__pfet_g5v0d10v5 ad=0.58 pd=4.29 as=0.58 ps=4.29 w=4 l=0.5
X3 a_n108_n400# a_n366_n497# a_n266_n400# B sky130_fd_pr__pfet_g5v0d10v5 ad=0.58 pd=4.29 as=0.58 ps=4.29 w=4 l=0.5
X4 a_208_n400# a_n366_n497# a_50_n400# B sky130_fd_pr__pfet_g5v0d10v5 ad=0.58 pd=4.29 as=0.58 ps=4.29 w=4 l=0.5
.ends

.subckt bandgap_m12 D G S B
Xsky130_fd_pr__pfet_g5v0d10v5_DQLY7V_1 B D G S S D S D sky130_fd_pr__pfet_g5v0d10v5_DQLY7V
.ends

.subckt sky130_fd_pr__res_high_po_0p35_PF4TA6 B R1 R2
X0 R2 R1 B sky130_fd_pr__res_high_po_0p35 l=49.12
.ends

.subckt sky130_fd_pr__res_high_po_0p35_Q87NDB B R1 R2
X0 R2 R1 B sky130_fd_pr__res_high_po_0p35 l=20.1
.ends

.subckt bandgap Vref VDD GND
Xbandgap_m7_0 Vg12 GND Vg12 GND bandgap_m7
Xbandgap_bjts_0 Ve1 Vg2 GND bandgap_bjts
Xbandgap_m3_0 Vg3 GND Vg3 GND bandgap_m3
Xbandgap_m3_1 Vg10 GND Vg3 GND bandgap_m3
Xbandgap_m3_2 bandgap_m3_3/D GND Vg10 GND bandgap_m3
Xbandgap_m1_0 Vg3 Vg2 sky130_fd_pr__pfet_g5v0d10v5_CEYAGG_0/S sky130_fd_pr__pfet_g5v0d10v5_CEYAGG_0/S
+ bandgap_m1
Xbandgap_m3_3 Vg12 bandgap_m3_3/D Vref GND bandgap_m3
Xsky130_fd_pr__nfet_g5v0d10v5_98BQ98_0 GND Vg5 Vs5 Vref sky130_fd_pr__nfet_g5v0d10v5_98BQ98
Xbandgap_m1_1 Vg10 Vg1 sky130_fd_pr__pfet_g5v0d10v5_CEYAGG_0/S sky130_fd_pr__pfet_g5v0d10v5_CEYAGG_0/S
+ bandgap_m1
Xsky130_fd_pr__res_high_po_0p69_TK733K_0 GND Ve1 Vg1 sky130_fd_pr__res_high_po_0p69_TK733K
Xsky130_fd_pr__pfet_g5v0d10v5_CEYAGG_0 VDD VDD sky130_fd_pr__pfet_g5v0d10v5_CEYAGG_0/S
+ Vg5 sky130_fd_pr__pfet_g5v0d10v5_CEYAGG
Xsky130_fd_pr__pfet_g5v0d10v5_CEYAGG_1 VDD VDD Vg12 Vg5 sky130_fd_pr__pfet_g5v0d10v5_CEYAGG
Xbandgap_m12_0 VDD Vg12 Vref VDD bandgap_m12
Xsky130_fd_pr__pfet_g5v0d10v5_CEYAGG_2 VDD VDD Vg5 Vg5 sky130_fd_pr__pfet_g5v0d10v5_CEYAGG
Xsky130_fd_pr__res_high_po_0p35_PF4TA6_0 GND Vs5 GND sky130_fd_pr__res_high_po_0p35_PF4TA6
Xsky130_fd_pr__res_high_po_0p35_Q87NDB_0 GND Vg1 Vref sky130_fd_pr__res_high_po_0p35_Q87NDB
Xsky130_fd_pr__res_high_po_0p35_Q87NDB_1 GND Vg2 Vref sky130_fd_pr__res_high_po_0p35_Q87NDB
.ends

.subckt instamp Vn Rgn Vp Rgp Vmid Vout Vref VDD GND Vout2 Vout3
XR1 GND Rgp Vout3 sky130_fd_pr__res_high_po_0p35_5E7VKC
XR2 GND Rgn Vout2 sky130_fd_pr__res_high_po_0p35_5E7VKC
XR3 GND Vout2 Vn4 sky130_fd_pr__res_high_po_0p35_T9W6LG
XR4 GND Vout3 Vp4 sky130_fd_pr__res_high_po_0p35_T9W6LG
XR5 GND Vp4 Vout5 sky130_fd_pr__res_high_po_0p35_T9W6LG
XR6 GND Vn4 Vout sky130_fd_pr__res_high_po_0p35_T9W6LG
Xopamp_0 Vref Vp4 Vn4 VDD opamp_0/Vg1 Vout GND opamp
Xopamp_1 Vref Vn Rgn VDD opamp_1/Vg1 Vout2 GND opamp
Xopamp_2 Vref Vp Rgp VDD opamp_2/Vg1 Vout3 GND opamp
Xbandgap_0 Vref VDD GND bandgap
Xopamp_3 Vref Vmid Vout5 VDD opamp_3/Vg1 Vout5 GND opamp
.ends

.subckt tt_um_jonathanwest3_instamp_sp2026 clk R1 rst_n ua[1] ua[3] ua[4] ua[5] ua[6]
+ ua[7] ui_in[0] ui_in[1] ui_in[2] ui_in[3] ui_in[4] ui_in[5] ui_in[6] ui_in[7] uio_in[0]
+ uio_in[1] uio_in[2] uio_in[3] uio_in[4] uio_in[5] uio_in[6] uio_in[7] uio_oe[0]
+ uio_oe[1] uio_oe[2] uio_oe[3] uio_oe[4] uio_oe[5] uio_oe[6] uio_oe[7] uio_out[0]
+ uio_out[1] uio_out[2] uio_out[3] uio_out[4] uio_out[5] uio_out[6] uio_out[7] uo_out[6]
+ uo_out[7] VDPWR VGND VAPWR R1_uq0 R1_uq1 R1_uq2 R1_uq3 R1_uq4
Xsky130_fd_pr__res_generic_m3_5VRV4L_39 ui_in[0] VGND sky130_fd_pr__res_generic_m3_5VRV4L
Xsky130_fd_pr__res_generic_m3_5VRV4L_28 uio_in[3] VGND sky130_fd_pr__res_generic_m3_5VRV4L
Xsky130_fd_pr__res_generic_m3_5VRV4L_17 uio_oe[1] VGND sky130_fd_pr__res_generic_m3_5VRV4L
Xsky130_fd_pr__res_generic_m3_5VRV4L_29 uio_in[2] VGND sky130_fd_pr__res_generic_m3_5VRV4L
Xsky130_fd_pr__res_generic_m3_5VRV4L_18 uio_oe[2] VGND sky130_fd_pr__res_generic_m3_5VRV4L
Xsky130_fd_pr__res_generic_m3_5VRV4L_19 uio_oe[3] VGND sky130_fd_pr__res_generic_m3_5VRV4L
Xsky130_fd_pr__res_generic_m3_5VRV4L_1 uio_out[5] VGND sky130_fd_pr__res_generic_m3_5VRV4L
Xsky130_fd_pr__res_generic_m3_5VRV4L_0 uio_out[4] VGND sky130_fd_pr__res_generic_m3_5VRV4L
Xsky130_fd_pr__res_generic_m3_5VRV4L_2 uio_out[6] VGND sky130_fd_pr__res_generic_m3_5VRV4L
Xsky130_fd_pr__res_generic_m3_5VRV4L_3 uio_out[7] VGND sky130_fd_pr__res_generic_m3_5VRV4L
Xsky130_fd_pr__res_generic_m3_5VRV4L_4 uio_out[3] VGND sky130_fd_pr__res_generic_m3_5VRV4L
Xsky130_fd_pr__res_generic_m3_5VRV4L_5 uio_out[2] VGND sky130_fd_pr__res_generic_m3_5VRV4L
Xsky130_fd_pr__res_generic_m3_5VRV4L_6 uio_out[1] VGND sky130_fd_pr__res_generic_m3_5VRV4L
Xsky130_fd_pr__res_generic_m3_5VRV4L_7 uio_out[0] VGND sky130_fd_pr__res_generic_m3_5VRV4L
Xsky130_fd_pr__res_generic_m3_5VRV4L_9 uo_out[6] VGND sky130_fd_pr__res_generic_m3_5VRV4L
Xsky130_fd_pr__res_generic_m3_5VRV4L_8 uo_out[7] VGND sky130_fd_pr__res_generic_m3_5VRV4L
Xsky130_fd_pr__res_generic_m3_5VRV4L_40 rst_n VGND sky130_fd_pr__res_generic_m3_5VRV4L
Xsky130_fd_pr__res_generic_m3_5VRV4L_41 clk VGND sky130_fd_pr__res_generic_m3_5VRV4L
Xsky130_fd_pr__res_generic_m3_5VRV4L_30 uio_in[1] VGND sky130_fd_pr__res_generic_m3_5VRV4L
Xsky130_fd_pr__res_generic_m3_5VRV4L_42 ena VGND sky130_fd_pr__res_generic_m3_5VRV4L
Xsky130_fd_pr__res_generic_m3_5VRV4L_31 uio_in[0] VGND sky130_fd_pr__res_generic_m3_5VRV4L
Xsky130_fd_pr__res_generic_m3_5VRV4L_20 uio_oe[4] VGND sky130_fd_pr__res_generic_m3_5VRV4L
Xsky130_fd_pr__res_generic_m3_5VRV4L_32 ui_in[7] VGND sky130_fd_pr__res_generic_m3_5VRV4L
Xsky130_fd_pr__res_generic_m3_5VRV4L_10 R1_uq3 VGND sky130_fd_pr__res_generic_m3_5VRV4L
Xsky130_fd_pr__res_generic_m3_5VRV4L_21 uio_oe[5] VGND sky130_fd_pr__res_generic_m3_5VRV4L
Xinstamp_0 ua[5] ua[4] ua[3] ua[3] instamp_0/Vmid instamp_0/Vout ua[3] VAPWR VGND
+ ua[3] ua[3] instamp
Xsky130_fd_pr__res_generic_m3_5VRV4L_34 ui_in[5] VGND sky130_fd_pr__res_generic_m3_5VRV4L
Xsky130_fd_pr__res_generic_m3_5VRV4L_33 ui_in[6] VGND sky130_fd_pr__res_generic_m3_5VRV4L
Xsky130_fd_pr__res_generic_m3_5VRV4L_12 R1_uq2 VGND sky130_fd_pr__res_generic_m3_5VRV4L
Xsky130_fd_pr__res_generic_m3_5VRV4L_11 R1_uq4 VGND sky130_fd_pr__res_generic_m3_5VRV4L
Xsky130_fd_pr__res_generic_m3_5VRV4L_22 uio_oe[6] VGND sky130_fd_pr__res_generic_m3_5VRV4L
Xsky130_fd_pr__res_generic_m3_5VRV4L_23 uio_oe[7] VGND sky130_fd_pr__res_generic_m3_5VRV4L
Xsky130_fd_pr__res_generic_m3_5VRV4L_35 ui_in[4] VGND sky130_fd_pr__res_generic_m3_5VRV4L
Xsky130_fd_pr__res_generic_m3_5VRV4L_24 uio_in[7] VGND sky130_fd_pr__res_generic_m3_5VRV4L
Xsky130_fd_pr__res_generic_m3_5VRV4L_13 R1_uq1 VGND sky130_fd_pr__res_generic_m3_5VRV4L
Xsky130_fd_pr__res_generic_m3_5VRV4L_36 ui_in[3] VGND sky130_fd_pr__res_generic_m3_5VRV4L
Xsky130_fd_pr__res_generic_m3_5VRV4L_25 uio_in[6] VGND sky130_fd_pr__res_generic_m3_5VRV4L
Xsky130_fd_pr__res_generic_m3_5VRV4L_14 R1 VGND sky130_fd_pr__res_generic_m3_5VRV4L
Xsky130_fd_pr__res_generic_m3_5VRV4L_37 ui_in[2] VGND sky130_fd_pr__res_generic_m3_5VRV4L
Xsky130_fd_pr__res_generic_m3_5VRV4L_26 uio_in[5] VGND sky130_fd_pr__res_generic_m3_5VRV4L
Xsky130_fd_pr__res_generic_m3_5VRV4L_15 R1_uq0 VGND sky130_fd_pr__res_generic_m3_5VRV4L
Xsky130_fd_pr__res_generic_m3_5VRV4L_38 ui_in[1] VGND sky130_fd_pr__res_generic_m3_5VRV4L
Xsky130_fd_pr__res_generic_m3_5VRV4L_27 uio_in[4] VGND sky130_fd_pr__res_generic_m3_5VRV4L
Xsky130_fd_pr__res_generic_m3_5VRV4L_16 uio_oe[0] VGND sky130_fd_pr__res_generic_m3_5VRV4L
.ends
