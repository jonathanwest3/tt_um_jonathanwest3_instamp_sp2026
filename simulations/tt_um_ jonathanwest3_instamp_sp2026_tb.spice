** sch_path: /home/jmwest/tt_um_jonathanwest3_instamp_sp2026/xschem/tt_um_ jonathanwest3_instamp_sp2026_tb.sch
**.subckt tt_um_ jonathanwest3_instamp_sp2026_tb
Vdd VDD 0 3.3
Vdiff Vp Vn sin(0 5m 1k) AC=1
Vmid Vmid 0 1.65
Vcm Vn Vmid 0 ac=0
Cref Vref 0 100n
Rg Rgn Rgp 17k
Rload Vout 0 1Meg
Cload Vout 0 10p
x1 net1 net2 net3 Vout Vref Rgp Vp Rgn Vn net4 net5 net6 net7 net8 net9 net10 net11 net12 net13 net14 net15 net16 net17 net18
+ net19 net20 net21 net22 net23 net24 net25 net26 net27 net28 net29 net30 net31 net32 net33 net34 net35 net36 net37 net38 net39 net40
+ net41 net42 net43 net44 net45 net46 0 VDD tt_um_jonathanwest3_instamp_sp2026
**** begin user architecture code

** opencircuitdesign pdks install
.lib /home/jmwest/.ciel/sky130A/libs.tech/combined/sky130.lib.spice tt

.option wnflag=1
.option savecurrents
.option rshunt=1e12

# if one of these is uncommented, it will
# override the subcircuit in the symbol
# from the cace extracction
.include ../netlist/rcx/tt_um_jonathanwest3_instamp_sp2026.spice
# from the mag extraction
#.include ../netlist/layout/instamp.spice

.save all
.control
if 1
op
write tt_um_jonathanwest3_instamp_sp2026_tb.raw
endif

set appendwrite
set gnuplot_terminal=png/quit

* write instamp_tb.raw
if 0
* differential gain tran
  destroy all
  foreach val 10k 5k 1k
    alter Rg = $val
    tran 10u 3m 1m
  end
  let Rg10k = tran1.v(vout)
  let Rg5k = tran2.v(vout)
  let Rg1k = tran3.v(vout)
  gnuplot tran Rg10k Rg5k Rg1k
*+ title 'Differential gain'
+ xlabel 'Time' ylabel 'Volts'
endif

# rise and fall times
if 0
let per=5u
let tstop=$&per*3
let tstep=per/1000
alter Rg=90k
alter @Vdiff[pulse] [ 0 100m $&per 1n 1n $&per $&tstop ]
tran $&tstep $&tstop
plot V(Vp,vmid) V(vout,vmid)
meas tran v_min MIN V(Vout)
meas tran v_pp PP V(Vout)
let v_high=(0.9*v_pp)+v_min
let v_low=(0.1*v_pp)+v_min
meas tran rise_time TRIG v(Vout) VAL='v_low' rise=1 targ v(vout) Val='v_high' RISE=1
let sr=(v_high-v_low)/rise_time
print sr

  gnuplot v_rise_fall V(vp,vmid) V(Vout,vmid)
+ title 'Rise and Fall Times'
+ xlabel 'Time (s)' ylabel 'Volts'

endif

if 0
ac dec 100 1 1Meg
let gain = db(V(Vout))
let cutoff_db = vecmax(gain)-3.0
meas ac bw WHEN gain=cutoff_db FALL =1
meas ac max_gain MAX gain
print bw max_gain
endif
* run ac on schematic as drawn
if 1
  destroy all
* differential gain ac
  ac dec 100 1 1Meg
  plot db(v(vout))
endif

* run ac cmrr and psrr sweeps
if 0
  destroy all
* differential gain ac
  alter vdiff ac=1
  alter vcm ac=0
  alter vdd ac=0
  foreach val 10k 5k 1k
    alter Rg = $val
    ac dec 100 1 1Meg
  end
  alter vdiff ac=0
  alter vcm ac=1
  alter vdd ac=0
  foreach val 10k 5k 1k
    alter Rg = $val
    ac dec 100 1 1Meg
  end
  alter vdiff ac=0
  alter vcm ac=0
  alter vdd ac=1
  foreach val 10k 5k 1k
    alter Rg = $val
    ac dec 100 1 1Meg
  end
  alter vdiff ac=0
  alter vcm ac=0
  alter vdd ac=0
  alter vmid ac=1
  foreach val 10k 5k 1k
    alter Rg = $val
    ac dec 100 1 1Meg
  end
  let Rg10k = db(ac1.v(vout))
  let Rg5k = db(ac2.v(vout))
  let Rg1k = db(ac3.v(vout))
  let Rg10k_cm = Rg10k-db(ac4.v(vout))
  let Rg5k_cm = Rg5k-db(ac5.v(vout))
  let Rg1k_cm = Rg1k-db(ac6.v(vout))
  let Rg10k_psh = Rg10k-db(ac7.v(vout))
  let Rg5k_psh = Rg5k-db(ac8.v(vout))
  let Rg1k_psh = Rg1k-db(ac9.v(vout))
  let Rg10k_vmid = Rg10k-db(ac10.v(vout))
  let Rg5k_vmid = Rg5k-db(ac11.v(vout))
  let Rg1k_vmid = Rg1k-db(ac12.v(vout))

  gnuplot ac Rg10k Rg5k Rg1k
+ title 'Differential gain'
+ xlabel 'Freq' ylabel 'Gain dB'
  gnuplot cmrr Rg10k_cm Rg5k_cm Rg1k_cm
+ title 'CMRR'
+ xlabel 'Freq' ylabel 'Gain dB'
  gnuplot psrr Rg10k_psh Rg5k_psh Rg1k_psh
+ title 'PSRR'
+ xlabel 'Freq' ylabel 'Gain dB'
  gnuplot vmid_rej Rg10k_vmid Rg5k_vmid Rg1k_vmid
+ title 'Vmid Rejection'
+ xlabel 'Freq' ylabel 'Gain dB'

endif

if 0
* common mode gain
  alter vdiff ac=0
  alter vcm ac=1
  foreach val 90k 5k 1k
    alter Rg = $val
    ac dec 100 1 10Meg
  end

  plot db(ac1.V(Vout)) db(ac2.V(Vout))
+ db(ac3.V(Vout)) title 'Mag Vout'

* power supply gain
  alter vcm ac=0
  alter vdd ac=1
  foreach val 90k 5k 1k
    alter Rg = $val
    ac dec 100 1 10Meg
  end

  plot db(ac4.V(Vout)) db(ac5.V(Vout))
+ db(ac6.V(Vout)) title 'Mag Vout'

endif

.endc

**** end user architecture code
**.ends

* expanding   symbol:  tt_um_jonathanwest3_instamp_sp2026.sym # of pins=54
** sym_path: /home/jmwest/tt_um_jonathanwest3_instamp_sp2026/xschem/tt_um_jonathanwest3_instamp_sp2026.sym
** sch_path: /home/jmwest/tt_um_jonathanwest3_instamp_sp2026/xschem/tt_um_jonathanwest3_instamp_sp2026.sch
.subckt tt_um_jonathanwest3_instamp_sp2026 clk ena rst_n ua[0] ua[1] ua[2] ua[3] ua[4] ua[5] ua[6] ua[7] ui_in[0] ui_in[1]
+ ui_in[2] ui_in[3] ui_in[4] ui_in[5] ui_in[6] ui_in[7] uio_in[0] uio_in[1] uio_in[2] uio_in[3] uio_in[4] uio_in[5] uio_in[6] uio_in[7]
+ uio_oe[0] uio_oe[1] uio_oe[2] uio_oe[3] uio_oe[4] uio_oe[5] uio_oe[6] uio_oe[7] uio_out[0] uio_out[1] uio_out[2] uio_out[3] uio_out[4]
+ uio_out[5] uio_out[6] uio_out[7] uo_out[0] uo_out[1] uo_out[2] uo_out[3] uo_out[4] uo_out[5] uo_out[6] uo_out[7] VDPWR VGND VAPWR
*.ipin VGND
*.ipin VAPWR
*.opin uo_out[0]
*.opin uo_out[1]
*.opin uo_out[2]
*.opin uo_out[3]
*.opin uo_out[4]
*.opin uo_out[5]
*.opin uo_out[6]
*.opin uo_out[7]
*.opin uio_out[0]
*.opin uio_out[1]
*.opin uio_out[2]
*.opin uio_out[3]
*.opin uio_out[4]
*.opin uio_out[5]
*.opin uio_out[6]
*.opin uio_out[7]
*.iopin ui_in[7]
*.iopin clk
*.iopin ena
*.iopin rst_n
*.iopin VDPWR
*.iopin uio_oe[0]
*.iopin uio_in[0]
*.iopin ui_in[6]
*.iopin ui_in[5]
*.iopin ui_in[4]
*.iopin ui_in[3]
*.iopin ui_in[2]
*.iopin ui_in[1]
*.iopin ui_in[0]
*.iopin ua[0]
*.iopin ua[1]
*.iopin ua[2]
*.iopin ua[3]
*.iopin ua[4]
*.iopin ua[5]
*.iopin ua[6]
*.iopin ua[7]
*.iopin uio_oe[1]
*.iopin uio_oe[2]
*.iopin uio_oe[3]
*.iopin uio_oe[4]
*.iopin uio_oe[5]
*.iopin uio_oe[6]
*.iopin uio_oe[7]
*.iopin uio_in[1]
*.iopin uio_in[2]
*.iopin uio_in[3]
*.iopin uio_in[4]
*.iopin uio_in[5]
*.iopin uio_in[6]
*.iopin uio_in[7]
x5 ua[5] ua[4] ua[3] ua[2] Vmid ua[0] ua[1] VAPWR VGND instamp
XR1 Vmid VAPWR VGND sky130_fd_pr__res_high_po_0p35 L=20 mult=1
XR2 VGND Vmid VGND sky130_fd_pr__res_high_po_0p35 L=20 mult=1
R3 VGND uo_out[0] sky130_fd_pr__res_generic_m3 W=1 L=1
R4 VGND uo_out[1] sky130_fd_pr__res_generic_m3 W=1 L=1
R5 VGND uo_out[2] sky130_fd_pr__res_generic_m3 W=1 L=1
R6 VGND uo_out[3] sky130_fd_pr__res_generic_m3 W=1 L=1
R7 VGND uo_out[4] sky130_fd_pr__res_generic_m3 W=1 L=1
R8 VGND uo_out[5] sky130_fd_pr__res_generic_m3 W=1 L=1
R9 VGND uo_out[6] sky130_fd_pr__res_generic_m3 W=1 L=1
R10 VGND uo_out[7] sky130_fd_pr__res_generic_m3 W=1 L=1
R11 VGND uio_out[0] sky130_fd_pr__res_generic_m3 W=1 L=1
R12 VGND uio_out[1] sky130_fd_pr__res_generic_m3 W=1 L=1
R13 VGND uio_out[2] sky130_fd_pr__res_generic_m3 W=1 L=1
R14 VGND uio_out[3] sky130_fd_pr__res_generic_m3 W=1 L=1
R15 VGND uio_out[4] sky130_fd_pr__res_generic_m3 W=1 L=1
R16 VGND uio_out[5] sky130_fd_pr__res_generic_m3 W=1 L=1
R17 VGND uio_out[6] sky130_fd_pr__res_generic_m3 W=1 L=1
R18 VGND uio_out[7] sky130_fd_pr__res_generic_m3 W=1 L=1
R19 VGND ui_in[0] sky130_fd_pr__res_generic_m3 W=1 L=1
R20 VGND ui_in[1] sky130_fd_pr__res_generic_m3 W=1 L=1
R21 VGND ui_in[2] sky130_fd_pr__res_generic_m3 W=1 L=1
R22 VGND ui_in[3] sky130_fd_pr__res_generic_m3 W=1 L=1
R23 VGND ui_in[4] sky130_fd_pr__res_generic_m3 W=1 L=1
R24 VGND ui_in[5] sky130_fd_pr__res_generic_m3 W=1 L=1
R25 VGND ui_in[6] sky130_fd_pr__res_generic_m3 W=1 L=1
R26 VGND ui_in[7] sky130_fd_pr__res_generic_m3 W=1 L=1
R27 VGND uio_in[0] sky130_fd_pr__res_generic_m3 W=1 L=1
R28 VGND uio_in[1] sky130_fd_pr__res_generic_m3 W=1 L=1
R29 VGND uio_in[2] sky130_fd_pr__res_generic_m3 W=1 L=1
R30 VGND uio_in[3] sky130_fd_pr__res_generic_m3 W=1 L=1
R31 VGND uio_in[4] sky130_fd_pr__res_generic_m3 W=1 L=1
R32 VGND uio_in[5] sky130_fd_pr__res_generic_m3 W=1 L=1
R33 VGND uio_in[6] sky130_fd_pr__res_generic_m3 W=1 L=1
R34 VGND uio_in[7] sky130_fd_pr__res_generic_m3 W=1 L=1
R41 VGND ua[6] sky130_fd_pr__res_generic_m3 W=1 L=1
R42 VGND ua[7] sky130_fd_pr__res_generic_m3 W=1 L=1
R35 VGND uio_oe[0] sky130_fd_pr__res_generic_m3 W=1 L=1
R36 VGND uio_oe[1] sky130_fd_pr__res_generic_m3 W=1 L=1
R37 VGND uio_oe[2] sky130_fd_pr__res_generic_m3 W=1 L=1
R38 VGND uio_oe[3] sky130_fd_pr__res_generic_m3 W=1 L=1
R39 VGND uio_oe[4] sky130_fd_pr__res_generic_m3 W=1 L=1
R40 VGND uio_oe[5] sky130_fd_pr__res_generic_m3 W=1 L=1
R43 VGND uio_oe[6] sky130_fd_pr__res_generic_m3 W=1 L=1
R44 VGND uio_oe[7] sky130_fd_pr__res_generic_m3 W=1 L=1
R45 VGND ena sky130_fd_pr__res_generic_m3 W=1 L=1
R46 VGND rst_n sky130_fd_pr__res_generic_m3 W=1 L=1
R47 VGND clk sky130_fd_pr__res_generic_m3 W=1 L=1
.ends

* expanding   symbol:  instamp.sym # of pins=9
** sym_path: /home/jmwest/tt_um_jonathanwest3_instamp_sp2026/xschem/instamp.sym
** sch_path: /home/jmwest/tt_um_jonathanwest3_instamp_sp2026/xschem/instamp.sch
.subckt instamp Vn Rgn Vp Rgp Vmid Vout Vref VDD GND
*.ipin Vp
*.ipin Vn
*.opin Vout
*.opin Vref
*.ipin Rgp
*.ipin Rgn
*.ipin Vmid
*.ipin GND
*.ipin VDD
XR1 Rgp Vout3 GND sky130_fd_pr__res_high_po_0p35 L=76.36 mult=1
XR2 Rgn Vout2 GND sky130_fd_pr__res_high_po_0p35 L=76.36 mult=1
XR3 Vout2 Vn4 GND sky130_fd_pr__res_high_po_0p35 L=51.36 mult=1
XR4 Vout3 Vp4 GND sky130_fd_pr__res_high_po_0p35 L=51.36 mult=1
XR5 Vp4 Vout5 GND sky130_fd_pr__res_high_po_0p35 L=51.36 mult=1
XR6 Vn4 Vout GND sky130_fd_pr__res_high_po_0p35 L=51.36 mult=1
x6 Vref Vout3 Vp Rgp VDD GND opamp
x2 Vref Vout2 Vn Rgn VDD GND opamp
x3 Vref Vout Vp4 Vn4 VDD GND opamp
x4 Vref Vout5 Vmid Vout5 VDD GND opamp
x1 Vref VDD GND bandgap
.ends

* expanding   symbol:  opamp.sym # of pins=6
** sym_path: /home/jmwest/tt_um_jonathanwest3_instamp_sp2026/xschem/opamp.sym
** sch_path: /home/jmwest/tt_um_jonathanwest3_instamp_sp2026/xschem/opamp.sch
.subckt opamp Vref Vout Vp Vn VDD GND
*.opin Vout
*.ipin Vref
*.ipin Vp
*.ipin Vn
*.ipin GND
*.ipin VDD
XM1 Vg1 Vg1 net1 GND sky130_fd_pr__nfet_g5v0d10v5 L=2 W=3.33 nf=1 ad=0.9657 as=0.9657 pd=7.24 ps=7.24 nrd=0.0870870870870871
+ nrs=0.0870870870870871 sa=0 sb=0 sd=0 mult=3 m=3
XM2 net1 Vg1 GND GND sky130_fd_pr__nfet_g5v0d10v5 L=5 W=5 nf=1 ad=1.45 as=1.45 pd=10.58 ps=10.58 nrd=0.058 nrs=0.058 sa=0 sb=0
+ sd=0 mult=1
XM4 net2 Vg1 GND GND sky130_fd_pr__nfet_g5v0d10v5 L=5 W=5 nf=1 ad=1.45 as=1.45 pd=10.58 ps=10.58 nrd=0.058 nrs=0.058 sa=0 sb=0
+ sd=0 mult=1
XM3 Vg5 Vg1 net2 GND sky130_fd_pr__nfet_g5v0d10v5 L=2 W=3.33 nf=1 ad=0.9657 as=0.9657 pd=7.24 ps=7.24 nrd=0.0870870870870871
+ nrs=0.0870870870870871 sa=0 sb=0 sd=0 mult=3 m=3
XMr1 net6 Vref GND GND sky130_fd_pr__nfet_g5v0d10v5 L=8 W=5 nf=1 ad=1.45 as=1.45 pd=10.58 ps=10.58 nrd=0.058 nrs=0.058 sa=0 sb=0
+ sd=0 mult=1
XMr2 VgR2 VgR2 VDD VDD sky130_fd_pr__pfet_g5v0d10v5 L=5 W=4 nf=1 ad=1.16 as=1.16 pd=8.58 ps=8.58 nrd=0.0725 nrs=0.0725 sa=0 sb=0
+ sd=0 mult=1
XMr3 Vg1 VgR2 VDD VDD sky130_fd_pr__pfet_g5v0d10v5 L=5 W=4 nf=1 ad=1.16 as=1.16 pd=8.58 ps=8.58 nrd=0.0725 nrs=0.0725 sa=0 sb=0
+ sd=0 mult=1
XM32 net3 Vg1 GND GND sky130_fd_pr__nfet_g5v0d10v5 L=5 W=10 nf=1 ad=2.9 as=2.9 pd=20.58 ps=20.58 nrd=0.029 nrs=0.029 sa=0 sb=0
+ sd=0 mult=1
XM31 Vs29 Vg1 net3 GND sky130_fd_pr__nfet_g5v0d10v5 L=2 W=6.66 nf=1 ad=1.9314 as=1.9314 pd=13.9 ps=13.9 nrd=0.0435435435435435
+ nrs=0.0435435435435435 sa=0 sb=0 sd=0 mult=3 m=3
XM15 Vg11 Vg1 Vd10 GND sky130_fd_pr__nfet_g5v0d10v5 L=2 W=14.3 nf=1 ad=4.147 as=4.147 pd=29.18 ps=29.18 nrd=0.0202797202797203
+ nrs=0.0202797202797203 sa=0 sb=0 sd=0 mult=7 m=7
XM16 Vd10 Vg1 GND GND sky130_fd_pr__nfet_g5v0d10v5 L=5 W=10 nf=1 ad=2.9 as=2.9 pd=20.58 ps=20.58 nrd=0.029 nrs=0.029 sa=0 sb=0
+ sd=0 mult=1
XM18 Vd9 Vg1 GND GND sky130_fd_pr__nfet_g5v0d10v5 L=5 W=10 nf=1 ad=2.9 as=2.9 pd=20.58 ps=20.58 nrd=0.029 nrs=0.029 sa=0 sb=0 sd=0
+ mult=1
XM17 Vg28 Vg1 Vd9 GND sky130_fd_pr__nfet_g5v0d10v5 L=2 W=14.3 nf=1 ad=4.147 as=4.147 pd=29.18 ps=29.18 nrd=0.0202797202797203
+ nrs=0.0202797202797203 sa=0 sb=0 sd=0 mult=7 m=7
XM20 Vg22 Vg1 GND GND sky130_fd_pr__nfet_g5v0d10v5 L=5 W=1.5 nf=1 ad=0.435 as=0.435 pd=3.58 ps=3.58 nrd=0.193333333333333
+ nrs=0.193333333333333 sa=0 sb=0 sd=0 mult=1
XM26 Vg26 Vg26 GND GND sky130_fd_pr__nfet_g5v0d10v5 L=0.5 W=5 nf=1 ad=1.45 as=1.45 pd=10.58 ps=10.58 nrd=0.058 nrs=0.058 sa=0 sb=0
+ sd=0 mult=5 m=5
XM25 Vd24 Vd24 Vg26 GND sky130_fd_pr__nfet_g5v0d10v5 L=0.5 W=5 nf=1 ad=1.45 as=1.45 pd=10.58 ps=10.58 nrd=0.058 nrs=0.058 sa=0
+ sb=0 sd=0 mult=5 m=5
XM23 Vg27 Vd24 Vg28 GND sky130_fd_pr__nfet_g5v0d10v5 L=0.5 W=10 nf=1 ad=2.9 as=2.9 pd=20.58 ps=20.58 nrd=0.029 nrs=0.029 sa=0 sb=0
+ sd=0 mult=5 m=5
XM28 Vout Vg28 GND GND sky130_fd_pr__nfet_g5v0d10v5 L=0.5 W=10 nf=1 ad=2.9 as=2.9 pd=20.58 ps=20.58 nrd=0.029 nrs=0.029 sa=0 sb=0
+ sd=0 mult=15 m=15
XM30 Vd30 Vn Vs29 GND sky130_fd_pr__nfet_g5v0d10v5 L=1.5 W=11.11 nf=1 ad=3.2219 as=3.2219 pd=22.8 ps=22.8 nrd=0.0261026102610261
+ nrs=0.0261026102610261 sa=0 sb=0 sd=0 mult=9 m=9
XM29 Vd29 Vp Vs29 GND sky130_fd_pr__nfet_g5v0d10v5 L=1.5 W=11.11 nf=1 ad=3.2219 as=3.2219 pd=22.8 ps=22.8 nrd=0.0261026102610261
+ nrs=0.0261026102610261 sa=0 sb=0 sd=0 mult=9 m=9
XM5 net4 Vg5 VDD VDD sky130_fd_pr__pfet_g5v0d10v5 L=5 W=5 nf=1 ad=1.45 as=1.45 pd=10.58 ps=10.58 nrd=0.058 nrs=0.058 sa=0 sb=0
+ sd=0 mult=3 m=3
XM6 Vg5 Vg5 net4 VDD sky130_fd_pr__pfet_g5v0d10v5 L=2 W=6.6 nf=1 ad=1.914 as=1.914 pd=13.78 ps=13.78 nrd=0.0439393939393939
+ nrs=0.0439393939393939 sa=0 sb=0 sd=0 mult=3 m=3
XM7 net5 Vg5 VDD VDD sky130_fd_pr__pfet_g5v0d10v5 L=5 W=10 nf=1 ad=2.9 as=2.9 pd=20.58 ps=20.58 nrd=0.029 nrs=0.029 sa=0 sb=0 sd=0
+ mult=3 m=3
XM8 Vd8 Vg5 net5 VDD sky130_fd_pr__pfet_g5v0d10v5 L=2 W=13.2 nf=1 ad=3.828 as=3.828 pd=26.98 ps=26.98 nrd=0.021969696969697
+ nrs=0.021969696969697 sa=0 sb=0 sd=0 mult=3 m=3
XM09 Vd9 Vp Vd8 Vd8 sky130_fd_pr__pfet_g5v0d10v5 L=1.5 W=22.22 nf=1 ad=6.4438 as=6.4438 pd=45.02 ps=45.02 nrd=0.0130513051305131
+ nrs=0.0130513051305131 sa=0 sb=0 sd=0 mult=9 m=9
XM010 Vd10 Vn Vd8 Vd8 sky130_fd_pr__pfet_g5v0d10v5 L=1.5 W=22.22 nf=1 ad=6.4438 as=6.4438 pd=45.02 ps=45.02 nrd=0.0130513051305131
+ nrs=0.0130513051305131 sa=0 sb=0 sd=0 mult=9 m=9
XM13 Vd29 Vg11 VDD VDD sky130_fd_pr__pfet_g5v0d10v5 L=2.5 W=10 nf=1 ad=2.9 as=2.9 pd=20.58 ps=20.58 nrd=0.029 nrs=0.029 sa=0 sb=0
+ sd=0 mult=5 m=5
XM14 Vg27 Vg11 Vd29 VDD sky130_fd_pr__pfet_g5v0d10v5 L=1 W=10 nf=1 ad=2.9 as=2.9 pd=20.58 ps=20.58 nrd=0.029 nrs=0.029 sa=0 sb=0
+ sd=0 mult=5 m=5
XM11 Vd30 Vg11 VDD VDD sky130_fd_pr__pfet_g5v0d10v5 L=2.5 W=10 nf=1 ad=2.9 as=2.9 pd=20.58 ps=20.58 nrd=0.029 nrs=0.029 sa=0 sb=0
+ sd=0 mult=5 m=5
XM12 Vg11 Vg11 Vd30 VDD sky130_fd_pr__pfet_g5v0d10v5 L=1 W=10 nf=1 ad=2.9 as=2.9 pd=20.58 ps=20.58 nrd=0.029 nrs=0.029 sa=0 sb=0
+ sd=0 mult=5 m=5
XM021 Vg21 Vg21 VDD VDD sky130_fd_pr__pfet_g5v0d10v5 L=0.5 W=15 nf=1 ad=4.35 as=4.35 pd=30.58 ps=30.58 nrd=0.0193333333333333
+ nrs=0.0193333333333333 sa=0 sb=0 sd=0 mult=5 m=5
XM022 Vg22 Vg22 Vg21 VDD sky130_fd_pr__pfet_g5v0d10v5 L=0.5 W=15 nf=1 ad=4.35 as=4.35 pd=30.58 ps=30.58 nrd=0.0193333333333333
+ nrs=0.0193333333333333 sa=0 sb=0 sd=0 mult=5 m=5
XM24 Vd24 Vg5 VDD VDD sky130_fd_pr__pfet_g5v0d10v5 L=5 W=4 nf=1 ad=1.16 as=1.16 pd=8.58 ps=8.58 nrd=0.0725 nrs=0.0725 sa=0 sb=0
+ sd=0 mult=1
XM27 Vout Vg27 VDD VDD sky130_fd_pr__pfet_g5v0d10v5 L=0.5 W=15 nf=1 ad=4.35 as=4.35 pd=30.58 ps=30.58 nrd=0.0193333333333333
+ nrs=0.0193333333333333 sa=0 sb=0 sd=0 mult=25 m=25
XM19 Vg28 Vg22 Vg27 VDD sky130_fd_pr__pfet_g5v0d10v5 L=0.5 W=10 nf=1 ad=2.9 as=2.9 pd=20.58 ps=20.58 nrd=0.029 nrs=0.029 sa=0 sb=0
+ sd=0 mult=15 m=15
Vmeas_Iref VgR2 net6 0
.save i(vmeas_iref)
XC1 Vg27 Vout sky130_fd_pr__cap_mim_m3_1 W=30 L=20 MF=4 m=4
XC2 Vg28 Vout sky130_fd_pr__cap_mim_m3_1 W=30 L=20 MF=4 m=4
.ends

* expanding   symbol:  bandgap.sym # of pins=3
** sym_path: /home/jmwest/tt_um_jonathanwest3_instamp_sp2026/xschem/bandgap.sym
** sch_path: /home/jmwest/tt_um_jonathanwest3_instamp_sp2026/xschem/bandgap.sch
.subckt bandgap Vref VDD GND
*.opin Vref
*.ipin GND
*.ipin VDD
XM4 Vg3 Vg3 GND GND sky130_fd_pr__nfet_g5v0d10v5 L=1 W=20 nf=1 ad=5.8 as=5.8 pd=40.58 ps=40.58 nrd=0.0145 nrs=0.0145 sa=0 sb=0
+ sd=0 mult=1
XQ1 GND GND Ve1 sky130_fd_pr__pnp_05v5_W3p40L3p40 m=24 mult=24
XQ2 GND GND Vg2 sky130_fd_pr__pnp_05v5_W3p40L3p40 m=1 mult=1
XM1 Vg10 Vg1 net1 net1 sky130_fd_pr__pfet_g5v0d10v5 L=1 W=20 nf=1 ad=5.8 as=5.8 pd=40.58 ps=40.58 nrd=0.0145 nrs=0.0145 sa=0 sb=0
+ sd=0 mult=1
XM2 Vg3 Vg2 net1 net1 sky130_fd_pr__pfet_g5v0d10v5 L=1 W=20 nf=1 ad=5.8 as=5.8 pd=40.58 ps=40.58 nrd=0.0145 nrs=0.0145 sa=0 sb=0
+ sd=0 mult=1
XM11 net1 Vg5 VDD VDD sky130_fd_pr__pfet_g5v0d10v5 L=1 W=1 nf=1 ad=0.29 as=0.29 pd=2.58 ps=2.58 nrd=0.29 nrs=0.29 sa=0 sb=0 sd=0
+ mult=1
XM3 Vg10 Vg3 GND GND sky130_fd_pr__nfet_g5v0d10v5 L=1 W=20 nf=1 ad=5.8 as=5.8 pd=40.58 ps=40.58 nrd=0.0145 nrs=0.0145 sa=0 sb=0
+ sd=0 mult=1
XM10 net2 Vg10 GND GND sky130_fd_pr__nfet_g5v0d10v5 L=1 W=20 nf=1 ad=5.8 as=5.8 pd=40.58 ps=40.58 nrd=0.0145 nrs=0.0145 sa=0 sb=0
+ sd=0 mult=1
XM8 Vg12 Vg5 VDD VDD sky130_fd_pr__pfet_g5v0d10v5 L=1 W=1 nf=1 ad=0.29 as=0.29 pd=2.58 ps=2.58 nrd=0.29 nrs=0.29 sa=0 sb=0 sd=0
+ mult=1
XM5 Vg5 Vg5 VDD VDD sky130_fd_pr__pfet_g5v0d10v5 L=1 W=1 nf=1 ad=0.29 as=0.29 pd=2.58 ps=2.58 nrd=0.29 nrs=0.29 sa=0 sb=0 sd=0
+ mult=1
XM12 Vref Vg12 VDD VDD sky130_fd_pr__pfet_g5v0d10v5 L=0.5 W=20 nf=1 ad=5.8 as=5.8 pd=40.58 ps=40.58 nrd=0.0145 nrs=0.0145 sa=0
+ sb=0 sd=0 mult=1
XM9 Vg12 Vref net2 GND sky130_fd_pr__nfet_g5v0d10v5 L=1 W=20 nf=1 ad=5.8 as=5.8 pd=40.58 ps=40.58 nrd=0.0145 nrs=0.0145 sa=0 sb=0
+ sd=0 mult=1
XM7a Vg12 Vg12 net6 GND sky130_fd_pr__nfet_g5v0d10v5 L=10 W=0.5 nf=1 ad=0.145 as=0.145 pd=1.58 ps=1.58 nrd=0.58 nrs=0.58 sa=0 sb=0
+ sd=0 mult=1
XM7b net6 Vg12 net5 GND sky130_fd_pr__nfet_g5v0d10v5 L=10 W=0.5 nf=1 ad=0.145 as=0.145 pd=1.58 ps=1.58 nrd=0.58 nrs=0.58 sa=0 sb=0
+ sd=0 mult=1
XM7c net5 Vg12 net4 GND sky130_fd_pr__nfet_g5v0d10v5 L=10 W=0.5 nf=1 ad=0.145 as=0.145 pd=1.58 ps=1.58 nrd=0.58 nrs=0.58 sa=0 sb=0
+ sd=0 mult=1
XM7d net4 Vg12 net3 GND sky130_fd_pr__nfet_g5v0d10v5 L=10 W=0.5 nf=1 ad=0.145 as=0.145 pd=1.58 ps=1.58 nrd=0.58 nrs=0.58 sa=0 sb=0
+ sd=0 mult=1
XM7e net3 Vg12 net11 GND sky130_fd_pr__nfet_g5v0d10v5 L=10 W=0.5 nf=1 ad=0.145 as=0.145 pd=1.58 ps=1.58 nrd=0.58 nrs=0.58 sa=0
+ sb=0 sd=0 mult=1
XM6 Vg5 Vref Vs5 GND sky130_fd_pr__nfet_g5v0d10v5 L=1 W=5 nf=1 ad=1.45 as=1.45 pd=10.58 ps=10.58 nrd=0.058 nrs=0.058 sa=0 sb=0
+ sd=0 mult=1
XR1 Vg2 Vref GND sky130_fd_pr__res_high_po_0p35 L=20.1 mult=1
XR2 Vg1 Vref GND sky130_fd_pr__res_high_po_0p35 L=20.1 mult=1
XR4 GND Vs5 GND sky130_fd_pr__res_high_po_0p35 L=49.12 mult=1
XM7f net11 Vg12 net10 GND sky130_fd_pr__nfet_g5v0d10v5 L=10 W=0.5 nf=1 ad=0.145 as=0.145 pd=1.58 ps=1.58 nrd=0.58 nrs=0.58 sa=0
+ sb=0 sd=0 mult=1
XM7g net10 Vg12 net9 GND sky130_fd_pr__nfet_g5v0d10v5 L=10 W=0.5 nf=1 ad=0.145 as=0.145 pd=1.58 ps=1.58 nrd=0.58 nrs=0.58 sa=0
+ sb=0 sd=0 mult=1
XM7h net9 Vg12 net8 GND sky130_fd_pr__nfet_g5v0d10v5 L=10 W=0.5 nf=1 ad=0.145 as=0.145 pd=1.58 ps=1.58 nrd=0.58 nrs=0.58 sa=0 sb=0
+ sd=0 mult=1
XM7I net8 Vg12 net7 GND sky130_fd_pr__nfet_g5v0d10v5 L=10 W=0.5 nf=1 ad=0.145 as=0.145 pd=1.58 ps=1.58 nrd=0.58 nrs=0.58 sa=0 sb=0
+ sd=0 mult=1
XM7J net7 Vg12 GND GND sky130_fd_pr__nfet_g5v0d10v5 L=10 W=0.5 nf=1 ad=0.145 as=0.145 pd=1.58 ps=1.58 nrd=0.58 nrs=0.58 sa=0 sb=0
+ sd=0 mult=1
XR3 Ve1 Vg1 GND sky130_fd_pr__res_high_po_0p69 L=6.99 mult=1
.ends

.GLOBAL VDD
.GLOBAL Vmid
.GLOBAL GND
.end
