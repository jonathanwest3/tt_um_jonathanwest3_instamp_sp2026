** sch_path: /home/jmwest/tt_um_jonathanwest3_instamp_sp2026/xschem/bandgap_tb.sch
**.subckt bandgap_tb
Vdd VDD 0 3.3
C1 Vref 0 100n
x1 Vref VDD 0 bandgap
**** begin user architecture code

** opencircuitdesign pdks install
.lib /home/jmwest/.ciel/sky130A/libs.tech/combined/sky130.lib.spice tt

.option wnflag=1
.include ../netlist/rcx/bandgap.spice
.save all
.control
set gnuplot_terminal=png/quit

op
#print x1.Vg1 x1.ve1 x1.vg10 x1.vg12 x1.vg2 x1.vg3 x1.vg5 x1.vs5
#tran 10n 10u
#plot V(Vref) title 'Vref vs time'

dc VDD 3.0 3.5 0.1
gnuplot bandgap_vref_vs_vdd V(Vref)
+ title 'Vref vs Vdd'
+ xlabel 'VDD' ylabel 'Vref'
#plot V(Vref) vs V(Vdd) title 'Vref vs Vdd'

dc VDD 3.0 3.5 0.02 TEMP -40 40 20
gnuplot bandgap_vref_vs_vdd_vs_temp V(Vref)
+ title 'Vref vs Vdd vs Temp (-40 to 40C)'
+ xlabel 'VDD' ylabel 'Vref'
#plot V(Vref) Vs V(Vdd) title 'Vref vs Vdd vs Temp'

#dc TEMP -40 40 10
#plot V(Vref) title 'Vref vs Temp at VDD=3.3'

.endc

**** end user architecture code
**.ends

* expanding   symbol:  bandgap.sym # of pins=3
** sym_path: /home/jmwest/tt_um_jonathanwest3_instamp_sp2026/xschem/bandgap.sym
** sch_path: /home/jmwest/tt_um_jonathanwest3_instamp_sp2026/xschem/bandgap.sch
.subckt bandgap Vref VDD GND
*.opin Vref
*.ipin GND
*.ipin VDD
XM4 Vg3 Vg3 GND GND sky130_fd_pr__nfet_g5v0d10v5 L=1 W=20 nf=1 ad=5.8 as=5.8 pd=40.58 ps=40.58 nrd=0.0145 nrs=0.0145 sa=0 sb=0
+ sd=0 mult=1
XQ1 GND GND Ve1 sky130_fd_pr__pnp_05v5_W3p40L3p40 m=24 mult=24
XQ2 GND GND Vg2 sky130_fd_pr__pnp_05v5_W3p40L3p40 m=1 mult=1
XM1 Vg10 Vg1 net1 net1 sky130_fd_pr__pfet_g5v0d10v5 L=1 W=20 nf=1 ad=5.8 as=5.8 pd=40.58 ps=40.58 nrd=0.0145 nrs=0.0145 sa=0 sb=0
+ sd=0 mult=1
XM2 Vg3 Vg2 net1 net1 sky130_fd_pr__pfet_g5v0d10v5 L=1 W=20 nf=1 ad=5.8 as=5.8 pd=40.58 ps=40.58 nrd=0.0145 nrs=0.0145 sa=0 sb=0
+ sd=0 mult=1
XM11 net1 Vg5 VDD VDD sky130_fd_pr__pfet_g5v0d10v5 L=1 W=1 nf=1 ad=0.29 as=0.29 pd=2.58 ps=2.58 nrd=0.29 nrs=0.29 sa=0 sb=0 sd=0
+ mult=1
XM3 Vg10 Vg3 GND GND sky130_fd_pr__nfet_g5v0d10v5 L=1 W=20 nf=1 ad=5.8 as=5.8 pd=40.58 ps=40.58 nrd=0.0145 nrs=0.0145 sa=0 sb=0
+ sd=0 mult=1
XM10 net2 Vg10 GND GND sky130_fd_pr__nfet_g5v0d10v5 L=1 W=20 nf=1 ad=5.8 as=5.8 pd=40.58 ps=40.58 nrd=0.0145 nrs=0.0145 sa=0 sb=0
+ sd=0 mult=1
XM8 Vg12 Vg5 VDD VDD sky130_fd_pr__pfet_g5v0d10v5 L=1 W=1 nf=1 ad=0.29 as=0.29 pd=2.58 ps=2.58 nrd=0.29 nrs=0.29 sa=0 sb=0 sd=0
+ mult=1
XM5 Vg5 Vg5 VDD VDD sky130_fd_pr__pfet_g5v0d10v5 L=1 W=1 nf=1 ad=0.29 as=0.29 pd=2.58 ps=2.58 nrd=0.29 nrs=0.29 sa=0 sb=0 sd=0
+ mult=1
XM12 Vref Vg12 VDD VDD sky130_fd_pr__pfet_g5v0d10v5 L=0.5 W=20 nf=1 ad=5.8 as=5.8 pd=40.58 ps=40.58 nrd=0.0145 nrs=0.0145 sa=0
+ sb=0 sd=0 mult=1
XM9 Vg12 Vref net2 GND sky130_fd_pr__nfet_g5v0d10v5 L=1 W=20 nf=1 ad=5.8 as=5.8 pd=40.58 ps=40.58 nrd=0.0145 nrs=0.0145 sa=0 sb=0
+ sd=0 mult=1
XM7a Vg12 Vg12 net6 GND sky130_fd_pr__nfet_g5v0d10v5 L=10 W=0.5 nf=1 ad=0.145 as=0.145 pd=1.58 ps=1.58 nrd=0.58 nrs=0.58 sa=0 sb=0
+ sd=0 mult=1
XM7b net6 Vg12 net5 GND sky130_fd_pr__nfet_g5v0d10v5 L=10 W=0.5 nf=1 ad=0.145 as=0.145 pd=1.58 ps=1.58 nrd=0.58 nrs=0.58 sa=0 sb=0
+ sd=0 mult=1
XM7c net5 Vg12 net4 GND sky130_fd_pr__nfet_g5v0d10v5 L=10 W=0.5 nf=1 ad=0.145 as=0.145 pd=1.58 ps=1.58 nrd=0.58 nrs=0.58 sa=0 sb=0
+ sd=0 mult=1
XM7d net4 Vg12 net3 GND sky130_fd_pr__nfet_g5v0d10v5 L=10 W=0.5 nf=1 ad=0.145 as=0.145 pd=1.58 ps=1.58 nrd=0.58 nrs=0.58 sa=0 sb=0
+ sd=0 mult=1
XM7e net3 Vg12 net11 GND sky130_fd_pr__nfet_g5v0d10v5 L=10 W=0.5 nf=1 ad=0.145 as=0.145 pd=1.58 ps=1.58 nrd=0.58 nrs=0.58 sa=0
+ sb=0 sd=0 mult=1
XM6 Vg5 Vref Vs5 GND sky130_fd_pr__nfet_g5v0d10v5 L=1 W=5 nf=1 ad=1.45 as=1.45 pd=10.58 ps=10.58 nrd=0.058 nrs=0.058 sa=0 sb=0
+ sd=0 mult=1
XR1 Vg2 Vref GND sky130_fd_pr__res_high_po_0p35 L=20.1 mult=1
XR2 Vg1 Vref GND sky130_fd_pr__res_high_po_0p35 L=20.1 mult=1
XR4 GND Vs5 GND sky130_fd_pr__res_high_po_0p35 L=49.12 mult=1
XM7f net11 Vg12 net10 GND sky130_fd_pr__nfet_g5v0d10v5 L=10 W=0.5 nf=1 ad=0.145 as=0.145 pd=1.58 ps=1.58 nrd=0.58 nrs=0.58 sa=0
+ sb=0 sd=0 mult=1
XM7g net10 Vg12 net9 GND sky130_fd_pr__nfet_g5v0d10v5 L=10 W=0.5 nf=1 ad=0.145 as=0.145 pd=1.58 ps=1.58 nrd=0.58 nrs=0.58 sa=0
+ sb=0 sd=0 mult=1
XM7h net9 Vg12 net8 GND sky130_fd_pr__nfet_g5v0d10v5 L=10 W=0.5 nf=1 ad=0.145 as=0.145 pd=1.58 ps=1.58 nrd=0.58 nrs=0.58 sa=0 sb=0
+ sd=0 mult=1
XM7I net8 Vg12 net7 GND sky130_fd_pr__nfet_g5v0d10v5 L=10 W=0.5 nf=1 ad=0.145 as=0.145 pd=1.58 ps=1.58 nrd=0.58 nrs=0.58 sa=0 sb=0
+ sd=0 mult=1
XM7J net7 Vg12 GND GND sky130_fd_pr__nfet_g5v0d10v5 L=10 W=0.5 nf=1 ad=0.145 as=0.145 pd=1.58 ps=1.58 nrd=0.58 nrs=0.58 sa=0 sb=0
+ sd=0 mult=1
XR3 Ve1 Vg1 GND sky130_fd_pr__res_high_po_0p69 L=6.99 mult=1
.ends

.GLOBAL VDD
.GLOBAL GND
.end
