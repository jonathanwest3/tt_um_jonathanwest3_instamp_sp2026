* NGSPICE file created from opamp.ext - technology: sky130A

X0 Vg27 Vg11 Vd29 VDD sky130_fd_pr__pfet_g5v0d10v5 ad=1.45 pd=10.29 as=2.9 ps=20.58 w=10 l=1
X1 Vd29 Vg11 Vg27 VDD sky130_fd_pr__pfet_g5v0d10v5 ad=1.45 pd=10.29 as=1.45 ps=10.29 w=10 l=1
X2 Vd29 Vg11 Vg27 VDD sky130_fd_pr__pfet_g5v0d10v5 ad=1.45 pd=10.29 as=1.45 ps=10.29 w=10 l=1
X3 Vg27 Vg11 Vd29 VDD sky130_fd_pr__pfet_g5v0d10v5 ad=2.9 pd=20.58 as=1.45 ps=10.29 w=10 l=1
X4 Vg27 Vg11 Vd29 VDD sky130_fd_pr__pfet_g5v0d10v5 ad=1.45 pd=10.29 as=1.45 ps=10.29 w=10 l=1
X5 Vd29 Vg11 VDD VDD sky130_fd_pr__pfet_g5v0d10v5 ad=1.45 pd=10.29 as=1.45 ps=10.29 w=10 l=2.5
X6 VDD Vg11 Vd29 VDD sky130_fd_pr__pfet_g5v0d10v5 ad=1.45 pd=10.29 as=1.45 ps=10.29 w=10 l=2.5
X7 VDD Vg11 Vd29 VDD sky130_fd_pr__pfet_g5v0d10v5 ad=1.45 pd=10.29 as=1.45 ps=10.29 w=10 l=2.5
X8 Vd29 Vg11 VDD VDD sky130_fd_pr__pfet_g5v0d10v5 ad=1.45 pd=10.29 as=2.9 ps=20.58 w=10 l=2.5
X9 Vd29 Vg11 VDD VDD sky130_fd_pr__pfet_g5v0d10v5 ad=2.9 pd=20.58 as=1.45 ps=10.29 w=10 l=2.5
X10 GND Vg1 Vg22 GND sky130_fd_pr__nfet_g5v0d10v5 ad=0.435 pd=3.58 as=0.435 ps=3.58 w=1.5 l=5
X11 Vd24 Vg5 VDD VDD sky130_fd_pr__pfet_g5v0d10v5 ad=1.16 pd=8.58 as=1.16 ps=8.58 w=4 l=5
X12 m07_08_0/m1_29362_10250# Vg5 Vd8 VDD sky130_fd_pr__pfet_g5v0d10v5 ad=1.914 pd=13.49 as=1.914 ps=13.49 w=13.2 l=2
X13 Vd8 Vg5 m07_08_0/m1_29362_10250# VDD sky130_fd_pr__pfet_g5v0d10v5 ad=1.914 pd=13.49 as=3.828 ps=26.98 w=13.2 l=2
X14 Vd8 Vg5 m07_08_0/m1_29362_10250# VDD sky130_fd_pr__pfet_g5v0d10v5 ad=3.828 pd=26.98 as=1.914 ps=13.49 w=13.2 l=2
X15 VDD Vg5 m07_08_0/m1_29362_10250# VDD sky130_fd_pr__pfet_g5v0d10v5 ad=1.45 pd=10.29 as=1.45 ps=10.29 w=10 l=5
X16 m07_08_0/m1_29362_10250# Vg5 VDD VDD sky130_fd_pr__pfet_g5v0d10v5 ad=1.45 pd=10.29 as=2.9 ps=20.58 w=10 l=5
X17 m07_08_0/m1_29362_10250# Vg5 VDD VDD sky130_fd_pr__pfet_g5v0d10v5 ad=2.9 pd=20.58 as=1.45 ps=10.29 w=10 l=5
X18 Vd10 Vg1 Vg11 GND sky130_fd_pr__nfet_g5v0d10v5 ad=4.147 pd=29.18 as=2.0735 ps=14.59 w=14.3 l=2
X19 Vd10 Vg1 Vg11 GND sky130_fd_pr__nfet_g5v0d10v5 ad=2.0735 pd=14.59 as=4.147 ps=29.18 w=14.3 l=2
X20 Vg11 Vg1 Vd10 GND sky130_fd_pr__nfet_g5v0d10v5 ad=2.0735 pd=14.59 as=2.0735 ps=14.59 w=14.3 l=2
X21 Vd10 Vg1 Vg11 GND sky130_fd_pr__nfet_g5v0d10v5 ad=2.0735 pd=14.59 as=2.0735 ps=14.59 w=14.3 l=2
X22 Vg11 Vg1 Vd10 GND sky130_fd_pr__nfet_g5v0d10v5 ad=2.0735 pd=14.59 as=2.0735 ps=14.59 w=14.3 l=2
X23 Vd10 Vg1 Vg11 GND sky130_fd_pr__nfet_g5v0d10v5 ad=2.0735 pd=14.59 as=2.0735 ps=14.59 w=14.3 l=2
X24 Vg11 Vg1 Vd10 GND sky130_fd_pr__nfet_g5v0d10v5 ad=2.0735 pd=14.59 as=2.0735 ps=14.59 w=14.3 l=2
X25 GND Vg1 Vd10 GND sky130_fd_pr__nfet_g5v0d10v5 ad=2.9 pd=20.58 as=2.9 ps=20.58 w=10 l=5
X26 Vs29 Vg1 m31_32_0/m1_21854_12984# GND sky130_fd_pr__nfet_g5v0d10v5 ad=0.9657 pd=6.95 as=0.9657 ps=6.95 w=6.66 l=2
X27 m31_32_0/m1_21854_12984# Vg1 Vs29 GND sky130_fd_pr__nfet_g5v0d10v5 ad=1.9314 pd=13.9 as=0.9657 ps=6.95 w=6.66 l=2
X28 m31_32_0/m1_21854_12984# Vg1 Vs29 GND sky130_fd_pr__nfet_g5v0d10v5 ad=0.9657 pd=6.95 as=1.9314 ps=13.9 w=6.66 l=2
X29 GND Vg1 m31_32_0/m1_21854_12984# GND sky130_fd_pr__nfet_g5v0d10v5 ad=41.035 pd=293.44 as=6.7628 ps=48.38 w=10 l=5
X30 Vd9 Vp Vd8 Vd8 sky130_fd_pr__pfet_g5v0d10v5 ad=6.4438 pd=45.02 as=3.2219 ps=22.51 w=22.22 l=1.5
X31 Vd9 Vp Vd8 Vd8 sky130_fd_pr__pfet_g5v0d10v5 ad=3.2219 pd=22.51 as=3.2219 ps=22.51 w=22.22 l=1.5
X32 Vd9 Vp Vd8 Vd8 sky130_fd_pr__pfet_g5v0d10v5 ad=3.2219 pd=22.51 as=3.2219 ps=22.51 w=22.22 l=1.5
X33 Vd9 Vp Vd8 Vd8 sky130_fd_pr__pfet_g5v0d10v5 ad=3.2219 pd=22.51 as=3.2219 ps=22.51 w=22.22 l=1.5
X34 Vd9 Vp Vd8 Vd8 sky130_fd_pr__pfet_g5v0d10v5 ad=3.2219 pd=22.51 as=6.4438 ps=45.02 w=22.22 l=1.5
X35 Vd8 Vp Vd9 Vd8 sky130_fd_pr__pfet_g5v0d10v5 ad=3.2219 pd=22.51 as=3.2219 ps=22.51 w=22.22 l=1.5
X36 Vd8 Vp Vd9 Vd8 sky130_fd_pr__pfet_g5v0d10v5 ad=3.2219 pd=22.51 as=3.2219 ps=22.51 w=22.22 l=1.5
X37 Vd8 Vp Vd9 Vd8 sky130_fd_pr__pfet_g5v0d10v5 ad=3.2219 pd=22.51 as=3.2219 ps=22.51 w=22.22 l=1.5
X38 Vd8 Vp Vd9 Vd8 sky130_fd_pr__pfet_g5v0d10v5 ad=3.2219 pd=22.51 as=3.2219 ps=22.51 w=22.22 l=1.5
X39 Vd10 Vn Vd8 Vd8 sky130_fd_pr__pfet_g5v0d10v5 ad=32.219 pd=225.10001 as=72.094 ps=504.16 w=22.22 l=1.5
X40 Vd10 Vn Vd8 Vd8 sky130_fd_pr__pfet_g5v0d10v5 ad=0 pd=0 as=0 ps=0 w=22.22 l=1.5
X41 Vd10 Vn Vd8 Vd8 sky130_fd_pr__pfet_g5v0d10v5 ad=0 pd=0 as=0 ps=0 w=22.22 l=1.5
X42 Vd10 Vn Vd8 Vd8 sky130_fd_pr__pfet_g5v0d10v5 ad=0 pd=0 as=0 ps=0 w=22.22 l=1.5
X43 Vd10 Vn Vd8 Vd8 sky130_fd_pr__pfet_g5v0d10v5 ad=0 pd=0 as=0 ps=0 w=22.22 l=1.5
X44 Vd8 Vn Vd10 Vd8 sky130_fd_pr__pfet_g5v0d10v5 ad=0 pd=0 as=0 ps=0 w=22.22 l=1.5
X45 Vd8 Vn Vd10 Vd8 sky130_fd_pr__pfet_g5v0d10v5 ad=0 pd=0 as=0 ps=0 w=22.22 l=1.5
X46 Vd8 Vn Vd10 Vd8 sky130_fd_pr__pfet_g5v0d10v5 ad=0 pd=0 as=0 ps=0 w=22.22 l=1.5
X47 Vd8 Vn Vd10 Vd8 sky130_fd_pr__pfet_g5v0d10v5 ad=0 pd=0 as=0 ps=0 w=22.22 l=1.5
X48 Vg5 Vg1 M03_04/sky130_fd_pr__nfet_g5v0d10v5_Y3KDPX_0/D GND sky130_fd_pr__nfet_g5v0d10v5 ad=0.48285 pd=3.62 as=0.48285 ps=3.62 w=3.33 l=2
X49 M03_04/sky130_fd_pr__nfet_g5v0d10v5_Y3KDPX_0/D Vg1 Vg5 GND sky130_fd_pr__nfet_g5v0d10v5 ad=0.9657 pd=7.24 as=0.48285 ps=3.62 w=3.33 l=2
X50 M03_04/sky130_fd_pr__nfet_g5v0d10v5_Y3KDPX_0/D Vg1 Vg5 GND sky130_fd_pr__nfet_g5v0d10v5 ad=0.48285 pd=3.62 as=0.9657 ps=7.24 w=3.33 l=2
X51 GND Vg1 M03_04/sky130_fd_pr__nfet_g5v0d10v5_Y3KDPX_0/D GND sky130_fd_pr__nfet_g5v0d10v5 ad=1.45 pd=10.58 as=1.45 ps=10.58 w=5 l=5
X52 Vout Vg27 VDD VDD sky130_fd_pr__pfet_g5v0d10v5 ad=2.175 pd=15.29 as=2.175 ps=15.29 w=15 l=0.5
X53 Vout Vg27 VDD VDD sky130_fd_pr__pfet_g5v0d10v5 ad=2.175 pd=15.29 as=2.175 ps=15.29 w=15 l=0.5
X54 Vout Vg27 VDD VDD sky130_fd_pr__pfet_g5v0d10v5 ad=2.175 pd=15.29 as=2.175 ps=15.29 w=15 l=0.5
X55 VDD Vg27 Vout VDD sky130_fd_pr__pfet_g5v0d10v5 ad=2.175 pd=15.29 as=2.175 ps=15.29 w=15 l=0.5
X56 Vout Vg27 VDD VDD sky130_fd_pr__pfet_g5v0d10v5 ad=2.175 pd=15.29 as=2.175 ps=15.29 w=15 l=0.5
X57 VDD Vg27 Vout VDD sky130_fd_pr__pfet_g5v0d10v5 ad=2.175 pd=15.29 as=2.175 ps=15.29 w=15 l=0.5
X58 Vout Vg27 VDD VDD sky130_fd_pr__pfet_g5v0d10v5 ad=2.175 pd=15.29 as=2.175 ps=15.29 w=15 l=0.5
X59 Vout Vg27 VDD VDD sky130_fd_pr__pfet_g5v0d10v5 ad=2.175 pd=15.29 as=2.175 ps=15.29 w=15 l=0.5
X60 Vout Vg27 VDD VDD sky130_fd_pr__pfet_g5v0d10v5 ad=2.175 pd=15.29 as=4.35 ps=30.58 w=15 l=0.5
X61 VDD Vg27 Vout VDD sky130_fd_pr__pfet_g5v0d10v5 ad=2.175 pd=15.29 as=2.175 ps=15.29 w=15 l=0.5
X62 Vout Vg27 VDD VDD sky130_fd_pr__pfet_g5v0d10v5 ad=2.175 pd=15.29 as=2.175 ps=15.29 w=15 l=0.5
X63 VDD Vg27 Vout VDD sky130_fd_pr__pfet_g5v0d10v5 ad=2.175 pd=15.29 as=2.175 ps=15.29 w=15 l=0.5
X64 VDD Vg27 Vout VDD sky130_fd_pr__pfet_g5v0d10v5 ad=2.175 pd=15.29 as=2.175 ps=15.29 w=15 l=0.5
X65 Vout Vg27 VDD VDD sky130_fd_pr__pfet_g5v0d10v5 ad=2.175 pd=15.29 as=2.175 ps=15.29 w=15 l=0.5
X66 VDD Vg27 Vout VDD sky130_fd_pr__pfet_g5v0d10v5 ad=2.175 pd=15.29 as=2.175 ps=15.29 w=15 l=0.5
X67 VDD Vg27 Vout VDD sky130_fd_pr__pfet_g5v0d10v5 ad=2.175 pd=15.29 as=2.175 ps=15.29 w=15 l=0.5
X68 Vout Vg27 VDD VDD sky130_fd_pr__pfet_g5v0d10v5 ad=2.175 pd=15.29 as=2.175 ps=15.29 w=15 l=0.5
X69 VDD Vg27 Vout VDD sky130_fd_pr__pfet_g5v0d10v5 ad=2.175 pd=15.29 as=2.175 ps=15.29 w=15 l=0.5
X70 Vout Vg27 VDD VDD sky130_fd_pr__pfet_g5v0d10v5 ad=2.175 pd=15.29 as=2.175 ps=15.29 w=15 l=0.5
X71 VDD Vg27 Vout VDD sky130_fd_pr__pfet_g5v0d10v5 ad=2.175 pd=15.29 as=2.175 ps=15.29 w=15 l=0.5
X72 Vout Vg27 VDD VDD sky130_fd_pr__pfet_g5v0d10v5 ad=2.175 pd=15.29 as=2.175 ps=15.29 w=15 l=0.5
X73 VDD Vg27 Vout VDD sky130_fd_pr__pfet_g5v0d10v5 ad=2.175 pd=15.29 as=2.175 ps=15.29 w=15 l=0.5
X74 VDD Vg27 Vout VDD sky130_fd_pr__pfet_g5v0d10v5 ad=2.175 pd=15.29 as=2.175 ps=15.29 w=15 l=0.5
X75 Vout Vg27 VDD VDD sky130_fd_pr__pfet_g5v0d10v5 ad=4.35 pd=30.58 as=2.175 ps=15.29 w=15 l=0.5
X76 VDD Vg27 Vout VDD sky130_fd_pr__pfet_g5v0d10v5 ad=2.175 pd=15.29 as=2.175 ps=15.29 w=15 l=0.5
X77 GND Vref VgR2 GND sky130_fd_pr__nfet_g5v0d10v5 ad=1.45 pd=10.58 as=1.45 ps=10.58 w=5 l=8
X78 VgR2 VgR2 VDD VDD sky130_fd_pr__pfet_g5v0d10v5 ad=1.16 pd=8.58 as=99.18 ps=700.82001 w=4 l=5
X79 Vg1 VgR2 VDD VDD sky130_fd_pr__pfet_g5v0d10v5 ad=1.16 pd=8.58 as=0 ps=0 w=4 l=5
X80 Vd9 Vg1 Vg28 GND sky130_fd_pr__nfet_g5v0d10v5 ad=19.488 pd=137.3 as=25.288 ps=178.46001 w=14.3 l=2
X81 Vd9 Vg1 Vg28 GND sky130_fd_pr__nfet_g5v0d10v5 ad=0 pd=0 as=0 ps=0 w=14.3 l=2
X82 Vg28 Vg1 Vd9 GND sky130_fd_pr__nfet_g5v0d10v5 ad=0 pd=0 as=0 ps=0 w=14.3 l=2
X83 Vd9 Vg1 Vg28 GND sky130_fd_pr__nfet_g5v0d10v5 ad=0 pd=0 as=0 ps=0 w=14.3 l=2
X84 Vg28 Vg1 Vd9 GND sky130_fd_pr__nfet_g5v0d10v5 ad=0 pd=0 as=0 ps=0 w=14.3 l=2
X85 Vd9 Vg1 Vg28 GND sky130_fd_pr__nfet_g5v0d10v5 ad=0 pd=0 as=0 ps=0 w=14.3 l=2
X86 Vg28 Vg1 Vd9 GND sky130_fd_pr__nfet_g5v0d10v5 ad=0 pd=0 as=0 ps=0 w=14.3 l=2
X87 GND Vg1 Vd9 GND sky130_fd_pr__nfet_g5v0d10v5 ad=0 pd=0 as=0 ps=0 w=10 l=5
X88 m25_26_0/m1_160_1028# m25_26_0/m1_160_1028# GND GND sky130_fd_pr__nfet_g5v0d10v5 ad=0.725 pd=5.29 as=0.725 ps=5.29 w=5 l=0.5
X89 m25_26_0/m1_160_1028# m25_26_0/m1_160_1028# GND GND sky130_fd_pr__nfet_g5v0d10v5 ad=0.725 pd=5.29 as=0.725 ps=5.29 w=5 l=0.5
X90 GND m25_26_0/m1_160_1028# m25_26_0/m1_160_1028# GND sky130_fd_pr__nfet_g5v0d10v5 ad=0.725 pd=5.29 as=1.45 ps=10.58 w=5 l=0.5
X91 GND m25_26_0/m1_160_1028# m25_26_0/m1_160_1028# GND sky130_fd_pr__nfet_g5v0d10v5 ad=1.45 pd=10.58 as=0.725 ps=5.29 w=5 l=0.5
X92 GND m25_26_0/m1_160_1028# m25_26_0/m1_160_1028# GND sky130_fd_pr__nfet_g5v0d10v5 ad=0.725 pd=5.29 as=0.725 ps=5.29 w=5 l=0.5
X93 Vd24 Vd24 m25_26_0/m1_160_1028# GND sky130_fd_pr__nfet_g5v0d10v5 ad=4.35 pd=31.74 as=8.7 ps=63.48 w=5 l=0.5
X94 Vd24 Vd24 m25_26_0/m1_160_1028# GND sky130_fd_pr__nfet_g5v0d10v5 ad=0 pd=0 as=0 ps=0 w=5 l=0.5
X95 m25_26_0/m1_160_1028# Vd24 Vd24 GND sky130_fd_pr__nfet_g5v0d10v5 ad=0 pd=0 as=0 ps=0 w=5 l=0.5
X96 m25_26_0/m1_160_1028# Vd24 Vd24 GND sky130_fd_pr__nfet_g5v0d10v5 ad=0 pd=0 as=0 ps=0 w=5 l=0.5
X97 m25_26_0/m1_160_1028# Vd24 Vd24 GND sky130_fd_pr__nfet_g5v0d10v5 ad=0 pd=0 as=0 ps=0 w=5 l=0.5
X98 Vg28 Vd24 Vg27 GND sky130_fd_pr__nfet_g5v0d10v5 ad=1.45 pd=10.29 as=2.9 ps=20.58 w=10 l=0.5
X99 Vg28 Vd24 Vg27 GND sky130_fd_pr__nfet_g5v0d10v5 ad=2.9 pd=20.58 as=1.45 ps=10.29 w=10 l=0.5
X100 Vg28 Vd24 Vg27 GND sky130_fd_pr__nfet_g5v0d10v5 ad=1.45 pd=10.29 as=1.45 ps=10.29 w=10 l=0.5
X101 Vg27 Vd24 Vg28 GND sky130_fd_pr__nfet_g5v0d10v5 ad=1.45 pd=10.29 as=1.45 ps=10.29 w=10 l=0.5
X102 Vg27 Vd24 Vg28 GND sky130_fd_pr__nfet_g5v0d10v5 ad=1.45 pd=10.29 as=1.45 ps=10.29 w=10 l=0.5
X103 Vg11 Vg11 Vd30 VDD sky130_fd_pr__pfet_g5v0d10v5 ad=8.7 pd=61.74 as=17.4 ps=123.48 w=10 l=1
X104 Vd30 Vg11 Vg11 VDD sky130_fd_pr__pfet_g5v0d10v5 ad=0 pd=0 as=0 ps=0 w=10 l=1
X105 Vd30 Vg11 Vg11 VDD sky130_fd_pr__pfet_g5v0d10v5 ad=0 pd=0 as=0 ps=0 w=10 l=1
X106 Vg11 Vg11 Vd30 VDD sky130_fd_pr__pfet_g5v0d10v5 ad=0 pd=0 as=0 ps=0 w=10 l=1
X107 Vg11 Vg11 Vd30 VDD sky130_fd_pr__pfet_g5v0d10v5 ad=0 pd=0 as=0 ps=0 w=10 l=1
X108 Vd30 Vg11 VDD VDD sky130_fd_pr__pfet_g5v0d10v5 ad=0 pd=0 as=0 ps=0 w=10 l=2.5
X109 VDD Vg11 Vd30 VDD sky130_fd_pr__pfet_g5v0d10v5 ad=0 pd=0 as=0 ps=0 w=10 l=2.5
X110 VDD Vg11 Vd30 VDD sky130_fd_pr__pfet_g5v0d10v5 ad=0 pd=0 as=0 ps=0 w=10 l=2.5
X111 Vd30 Vg11 VDD VDD sky130_fd_pr__pfet_g5v0d10v5 ad=0 pd=0 as=0 ps=0 w=10 l=2.5
X112 Vd30 Vg11 VDD VDD sky130_fd_pr__pfet_g5v0d10v5 ad=0 pd=0 as=0 ps=0 w=10 l=2.5
X113 Vg27 Vout sky130_fd_pr__cap_mim_m3_1 l=20 w=30
X114 Vg27 Vout sky130_fd_pr__cap_mim_m3_1 l=20 w=30
X115 Vg27 Vout sky130_fd_pr__cap_mim_m3_1 l=20 w=30
X116 Vg27 Vout sky130_fd_pr__cap_mim_m3_1 l=20 w=30
X117 Vg28 Vout sky130_fd_pr__cap_mim_m3_1 l=20 w=30
X118 Vg28 Vout sky130_fd_pr__cap_mim_m3_1 l=20 w=30
X119 Vg28 Vout sky130_fd_pr__cap_mim_m3_1 l=20 w=30
X120 Vg28 Vout sky130_fd_pr__cap_mim_m3_1 l=20 w=30
X121 Vg1 Vg1 m01_02/sky130_fd_pr__nfet_g5v0d10v5_Y3KDPX_0/D GND sky130_fd_pr__nfet_g5v0d10v5 ad=1.9314 pd=14.48 as=3.3814 ps=25.06 w=3.33 l=2
X122 m01_02/sky130_fd_pr__nfet_g5v0d10v5_Y3KDPX_0/D Vg1 Vg1 GND sky130_fd_pr__nfet_g5v0d10v5 ad=0 pd=0 as=0 ps=0 w=3.33 l=2
X123 m01_02/sky130_fd_pr__nfet_g5v0d10v5_Y3KDPX_0/D Vg1 Vg1 GND sky130_fd_pr__nfet_g5v0d10v5 ad=0 pd=0 as=0 ps=0 w=3.33 l=2
X124 GND Vg1 m01_02/sky130_fd_pr__nfet_g5v0d10v5_Y3KDPX_0/D GND sky130_fd_pr__nfet_g5v0d10v5 ad=0 pd=0 as=0 ps=0 w=5 l=5
X125 Vout Vg28 GND GND sky130_fd_pr__nfet_g5v0d10v5 ad=1.45 pd=10.29 as=1.45 ps=10.29 w=10 l=0.5
X126 Vout Vg28 GND GND sky130_fd_pr__nfet_g5v0d10v5 ad=1.45 pd=10.29 as=1.45 ps=10.29 w=10 l=0.5
X127 GND Vg28 Vout GND sky130_fd_pr__nfet_g5v0d10v5 ad=1.45 pd=10.29 as=1.45 ps=10.29 w=10 l=0.5
X128 Vout Vg28 GND GND sky130_fd_pr__nfet_g5v0d10v5 ad=1.45 pd=10.29 as=1.45 ps=10.29 w=10 l=0.5
X129 Vout Vg28 GND GND sky130_fd_pr__nfet_g5v0d10v5 ad=1.45 pd=10.29 as=1.45 ps=10.29 w=10 l=0.5
X130 Vout Vg28 GND GND sky130_fd_pr__nfet_g5v0d10v5 ad=1.45 pd=10.29 as=1.45 ps=10.29 w=10 l=0.5
X131 GND Vg28 Vout GND sky130_fd_pr__nfet_g5v0d10v5 ad=1.45 pd=10.29 as=1.45 ps=10.29 w=10 l=0.5
X132 Vout Vg28 GND GND sky130_fd_pr__nfet_g5v0d10v5 ad=1.45 pd=10.29 as=1.45 ps=10.29 w=10 l=0.5
X133 GND Vg28 Vout GND sky130_fd_pr__nfet_g5v0d10v5 ad=1.45 pd=10.29 as=1.45 ps=10.29 w=10 l=0.5
X134 GND Vg28 Vout GND sky130_fd_pr__nfet_g5v0d10v5 ad=1.45 pd=10.29 as=2.9 ps=20.58 w=10 l=0.5
X135 GND Vg28 Vout GND sky130_fd_pr__nfet_g5v0d10v5 ad=2.9 pd=20.58 as=1.45 ps=10.29 w=10 l=0.5
X136 GND Vg28 Vout GND sky130_fd_pr__nfet_g5v0d10v5 ad=1.45 pd=10.29 as=1.45 ps=10.29 w=10 l=0.5
X137 GND Vg28 Vout GND sky130_fd_pr__nfet_g5v0d10v5 ad=1.45 pd=10.29 as=1.45 ps=10.29 w=10 l=0.5
X138 GND Vg28 Vout GND sky130_fd_pr__nfet_g5v0d10v5 ad=1.45 pd=10.29 as=1.45 ps=10.29 w=10 l=0.5
X139 Vout Vg28 GND GND sky130_fd_pr__nfet_g5v0d10v5 ad=1.45 pd=10.29 as=1.45 ps=10.29 w=10 l=0.5
X140 Vs29 Vp Vd29 GND sky130_fd_pr__nfet_g5v0d10v5 ad=1.61095 pd=11.4 as=1.61095 ps=11.4 w=11.11 l=1.5
X141 Vs29 Vp Vd29 GND sky130_fd_pr__nfet_g5v0d10v5 ad=1.61095 pd=11.4 as=1.61095 ps=11.4 w=11.11 l=1.5
X142 Vs29 Vp Vd29 GND sky130_fd_pr__nfet_g5v0d10v5 ad=1.61095 pd=11.4 as=3.2219 ps=22.8 w=11.11 l=1.5
X143 Vd29 Vp Vs29 GND sky130_fd_pr__nfet_g5v0d10v5 ad=1.61095 pd=11.4 as=1.61095 ps=11.4 w=11.11 l=1.5
X144 Vd29 Vp Vs29 GND sky130_fd_pr__nfet_g5v0d10v5 ad=1.61095 pd=11.4 as=1.61095 ps=11.4 w=11.11 l=1.5
X145 Vd29 Vp Vs29 GND sky130_fd_pr__nfet_g5v0d10v5 ad=1.61095 pd=11.4 as=1.61095 ps=11.4 w=11.11 l=1.5
X146 Vd29 Vp Vs29 GND sky130_fd_pr__nfet_g5v0d10v5 ad=1.61095 pd=11.4 as=1.61095 ps=11.4 w=11.11 l=1.5
X147 Vs29 Vp Vd29 GND sky130_fd_pr__nfet_g5v0d10v5 ad=3.2219 pd=22.8 as=1.61095 ps=11.4 w=11.11 l=1.5
X148 Vs29 Vp Vd29 GND sky130_fd_pr__nfet_g5v0d10v5 ad=1.61095 pd=11.4 as=1.61095 ps=11.4 w=11.11 l=1.5
X149 Vs29 Vn Vd30 GND sky130_fd_pr__nfet_g5v0d10v5 ad=36.0818 pd=255.8 as=16.1095 ps=114 w=11.11 l=1.5
X150 Vs29 Vn Vd30 GND sky130_fd_pr__nfet_g5v0d10v5 ad=0 pd=0 as=0 ps=0 w=11.11 l=1.5
X151 Vs29 Vn Vd30 GND sky130_fd_pr__nfet_g5v0d10v5 ad=0 pd=0 as=0 ps=0 w=11.11 l=1.5
X152 Vd30 Vn Vs29 GND sky130_fd_pr__nfet_g5v0d10v5 ad=0 pd=0 as=0 ps=0 w=11.11 l=1.5
X153 Vd30 Vn Vs29 GND sky130_fd_pr__nfet_g5v0d10v5 ad=0 pd=0 as=0 ps=0 w=11.11 l=1.5
X154 Vd30 Vn Vs29 GND sky130_fd_pr__nfet_g5v0d10v5 ad=0 pd=0 as=0 ps=0 w=11.11 l=1.5
X155 Vd30 Vn Vs29 GND sky130_fd_pr__nfet_g5v0d10v5 ad=0 pd=0 as=0 ps=0 w=11.11 l=1.5
X156 Vs29 Vn Vd30 GND sky130_fd_pr__nfet_g5v0d10v5 ad=0 pd=0 as=0 ps=0 w=11.11 l=1.5
X157 Vs29 Vn Vd30 GND sky130_fd_pr__nfet_g5v0d10v5 ad=0 pd=0 as=0 ps=0 w=11.11 l=1.5
X158 VDD m21_22_0/G m21_22_0/G VDD sky130_fd_pr__pfet_g5v0d10v5 ad=4.35 pd=30.58 as=2.175 ps=15.29 w=15 l=0.5
X159 VDD m21_22_0/G m21_22_0/G VDD sky130_fd_pr__pfet_g5v0d10v5 ad=2.175 pd=15.29 as=2.175 ps=15.29 w=15 l=0.5
X160 m21_22_0/G m21_22_0/G VDD VDD sky130_fd_pr__pfet_g5v0d10v5 ad=2.175 pd=15.29 as=2.175 ps=15.29 w=15 l=0.5
X161 VDD m21_22_0/G m21_22_0/G VDD sky130_fd_pr__pfet_g5v0d10v5 ad=2.175 pd=15.29 as=4.35 ps=30.58 w=15 l=0.5
X162 m21_22_0/G m21_22_0/G VDD VDD sky130_fd_pr__pfet_g5v0d10v5 ad=2.175 pd=15.29 as=2.175 ps=15.29 w=15 l=0.5
X163 m21_22_0/G Vg22 Vg22 VDD sky130_fd_pr__pfet_g5v0d10v5 ad=26.1 pd=183.48 as=13.05 ps=91.74 w=15 l=0.5
X164 m21_22_0/G Vg22 Vg22 VDD sky130_fd_pr__pfet_g5v0d10v5 ad=0 pd=0 as=0 ps=0 w=15 l=0.5
X165 Vg22 Vg22 m21_22_0/G VDD sky130_fd_pr__pfet_g5v0d10v5 ad=0 pd=0 as=0 ps=0 w=15 l=0.5
X166 m21_22_0/G Vg22 Vg22 VDD sky130_fd_pr__pfet_g5v0d10v5 ad=0 pd=0 as=0 ps=0 w=15 l=0.5
X167 Vg22 Vg22 m21_22_0/G VDD sky130_fd_pr__pfet_g5v0d10v5 ad=0 pd=0 as=0 ps=0 w=15 l=0.5
X168 Vg27 Vg22 Vg28 VDD sky130_fd_pr__pfet_g5v0d10v5 ad=1.45 pd=10.29 as=1.45 ps=10.29 w=10 l=0.5
X169 Vg27 Vg22 Vg28 VDD sky130_fd_pr__pfet_g5v0d10v5 ad=1.45 pd=10.29 as=1.45 ps=10.29 w=10 l=0.5
X170 Vg27 Vg22 Vg28 VDD sky130_fd_pr__pfet_g5v0d10v5 ad=1.45 pd=10.29 as=1.45 ps=10.29 w=10 l=0.5
X171 Vg28 Vg22 Vg27 VDD sky130_fd_pr__pfet_g5v0d10v5 ad=1.45 pd=10.29 as=1.45 ps=10.29 w=10 l=0.5
X172 Vg27 Vg22 Vg28 VDD sky130_fd_pr__pfet_g5v0d10v5 ad=1.45 pd=10.29 as=1.45 ps=10.29 w=10 l=0.5
X173 Vg27 Vg22 Vg28 VDD sky130_fd_pr__pfet_g5v0d10v5 ad=1.45 pd=10.29 as=1.45 ps=10.29 w=10 l=0.5
X174 Vg27 Vg22 Vg28 VDD sky130_fd_pr__pfet_g5v0d10v5 ad=1.45 pd=10.29 as=1.45 ps=10.29 w=10 l=0.5
X175 Vg28 Vg22 Vg27 VDD sky130_fd_pr__pfet_g5v0d10v5 ad=1.45 pd=10.29 as=1.45 ps=10.29 w=10 l=0.5
X176 Vg27 Vg22 Vg28 VDD sky130_fd_pr__pfet_g5v0d10v5 ad=1.45 pd=10.29 as=1.45 ps=10.29 w=10 l=0.5
X177 Vg28 Vg22 Vg27 VDD sky130_fd_pr__pfet_g5v0d10v5 ad=1.45 pd=10.29 as=1.45 ps=10.29 w=10 l=0.5
X178 Vg28 Vg22 Vg27 VDD sky130_fd_pr__pfet_g5v0d10v5 ad=1.45 pd=10.29 as=2.9 ps=20.58 w=10 l=0.5
X179 Vg28 Vg22 Vg27 VDD sky130_fd_pr__pfet_g5v0d10v5 ad=2.9 pd=20.58 as=1.45 ps=10.29 w=10 l=0.5
X180 Vg28 Vg22 Vg27 VDD sky130_fd_pr__pfet_g5v0d10v5 ad=1.45 pd=10.29 as=1.45 ps=10.29 w=10 l=0.5
X181 Vg28 Vg22 Vg27 VDD sky130_fd_pr__pfet_g5v0d10v5 ad=1.45 pd=10.29 as=1.45 ps=10.29 w=10 l=0.5
X182 Vg28 Vg22 Vg27 VDD sky130_fd_pr__pfet_g5v0d10v5 ad=1.45 pd=10.29 as=1.45 ps=10.29 w=10 l=0.5
X183 m5_m6_0/m1_4014_7500# Vg5 VDD VDD sky130_fd_pr__pfet_g5v0d10v5 ad=1.45 pd=10.58 as=0.725 ps=5.29 w=5 l=5
X184 VDD Vg5 m5_m6_0/m1_4014_7500# VDD sky130_fd_pr__pfet_g5v0d10v5 ad=0.725 pd=5.29 as=0.725 ps=5.29 w=5 l=5
X185 m5_m6_0/m1_4014_7500# Vg5 VDD VDD sky130_fd_pr__pfet_g5v0d10v5 ad=0.725 pd=5.29 as=1.45 ps=10.58 w=5 l=5
X186 m5_m6_0/m1_4014_7500# Vg5 Vg5 VDD sky130_fd_pr__pfet_g5v0d10v5 ad=0.957 pd=6.89 as=0.957 ps=6.89 w=6.6 l=2
X187 Vg5 Vg5 m5_m6_0/m1_4014_7500# VDD sky130_fd_pr__pfet_g5v0d10v5 ad=1.914 pd=13.78 as=0.957 ps=6.89 w=6.6 l=2
X188 Vg5 Vg5 m5_m6_0/m1_4014_7500# VDD sky130_fd_pr__pfet_g5v0d10v5 ad=0.957 pd=6.89 as=1.914 ps=13.78 w=6.6 l=2
