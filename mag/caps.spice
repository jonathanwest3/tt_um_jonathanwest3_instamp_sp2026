* NGSPICE file created from caps.ext - technology: sky130A

X0 M4 M3 sky130_fd_pr__cap_mim_m3_1 l=20 w=20
X1 M4 M3 sky130_fd_pr__cap_mim_m3_1 l=20 w=20
X2 M4 M3 sky130_fd_pr__cap_mim_m3_1 l=20 w=20
X3 M4 M3 sky130_fd_pr__cap_mim_m3_1 l=20 w=20
