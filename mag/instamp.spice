* SPICE3 file created from instamp.ext - technology: sky130A

X0 Vout3 Rgp GND sky130_fd_pr__res_high_po_0p35 l=76.36
X1 Vout2 Rgn GND sky130_fd_pr__res_high_po_0p35 l=76.36
X2 Vn4 Vout2 GND sky130_fd_pr__res_high_po_0p35 l=51.36
X3 Vp4 Vout3 GND sky130_fd_pr__res_high_po_0p35 l=51.36
X4 Vout5 Vp4 GND sky130_fd_pr__res_high_po_0p35 l=51.36
X5 Vout Vn4 GND sky130_fd_pr__res_high_po_0p35 l=51.36
X6 opamp_0/Vg27 opamp_0/Vg11 opamp_0/Vd29 VDD sky130_fd_pr__pfet_g5v0d10v5 ad=1.45 pd=10.29 as=2.9 ps=20.58 w=10 l=1
X7 opamp_0/Vd29 opamp_0/Vg11 opamp_0/Vg27 VDD sky130_fd_pr__pfet_g5v0d10v5 ad=1.45 pd=10.29 as=1.45 ps=10.29 w=10 l=1
X8 opamp_0/Vd29 opamp_0/Vg11 opamp_0/Vg27 VDD sky130_fd_pr__pfet_g5v0d10v5 ad=1.45 pd=10.29 as=1.45 ps=10.29 w=10 l=1
X9 opamp_0/Vg27 opamp_0/Vg11 opamp_0/Vd29 VDD sky130_fd_pr__pfet_g5v0d10v5 ad=2.9 pd=20.58 as=1.45 ps=10.29 w=10 l=1
X10 opamp_0/Vg27 opamp_0/Vg11 opamp_0/Vd29 VDD sky130_fd_pr__pfet_g5v0d10v5 ad=1.45 pd=10.29 as=1.45 ps=10.29 w=10 l=1
X11 opamp_0/Vd29 opamp_0/Vg11 VDD VDD sky130_fd_pr__pfet_g5v0d10v5 ad=1.45 pd=10.29 as=1.45 ps=10.29 w=10 l=2.5
X12 VDD opamp_0/Vg11 opamp_0/Vd29 VDD sky130_fd_pr__pfet_g5v0d10v5 ad=1.45 pd=10.29 as=1.45 ps=10.29 w=10 l=2.5
X13 VDD opamp_0/Vg11 opamp_0/Vd29 VDD sky130_fd_pr__pfet_g5v0d10v5 ad=1.45 pd=10.29 as=1.45 ps=10.29 w=10 l=2.5
X14 opamp_0/Vd29 opamp_0/Vg11 VDD VDD sky130_fd_pr__pfet_g5v0d10v5 ad=1.45 pd=10.29 as=2.9 ps=20.58 w=10 l=2.5
X15 opamp_0/Vd29 opamp_0/Vg11 VDD VDD sky130_fd_pr__pfet_g5v0d10v5 ad=2.9 pd=20.58 as=1.45 ps=10.29 w=10 l=2.5
X16 GND opamp_0/Vg1 opamp_0/Vg22 GND sky130_fd_pr__nfet_g5v0d10v5 ad=0.435 pd=3.58 as=0.435 ps=3.58 w=1.5 l=5
X17 opamp_0/Vd24 opamp_0/Vg5 VDD VDD sky130_fd_pr__pfet_g5v0d10v5 ad=1.16 pd=8.58 as=1.16 ps=8.58 w=4 l=5
X18 opamp_0/m07_08_0/m1_29362_10250# opamp_0/Vg5 opamp_0/Vd8 VDD sky130_fd_pr__pfet_g5v0d10v5 ad=1.914 pd=13.49 as=1.914 ps=13.49 w=13.2 l=2
X19 opamp_0/Vd8 opamp_0/Vg5 opamp_0/m07_08_0/m1_29362_10250# VDD sky130_fd_pr__pfet_g5v0d10v5 ad=1.914 pd=13.49 as=3.828 ps=26.98 w=13.2 l=2
X20 opamp_0/Vd8 opamp_0/Vg5 opamp_0/m07_08_0/m1_29362_10250# VDD sky130_fd_pr__pfet_g5v0d10v5 ad=3.828 pd=26.98 as=1.914 ps=13.49 w=13.2 l=2
X21 VDD opamp_0/Vg5 opamp_0/m07_08_0/m1_29362_10250# VDD sky130_fd_pr__pfet_g5v0d10v5 ad=1.45 pd=10.29 as=1.45 ps=10.29 w=10 l=5
X22 opamp_0/m07_08_0/m1_29362_10250# opamp_0/Vg5 VDD VDD sky130_fd_pr__pfet_g5v0d10v5 ad=1.45 pd=10.29 as=2.9 ps=20.58 w=10 l=5
X23 opamp_0/m07_08_0/m1_29362_10250# opamp_0/Vg5 VDD VDD sky130_fd_pr__pfet_g5v0d10v5 ad=2.9 pd=20.58 as=1.45 ps=10.29 w=10 l=5
X24 opamp_0/Vd10 opamp_0/Vg1 opamp_0/Vg11 GND sky130_fd_pr__nfet_g5v0d10v5 ad=4.147 pd=29.18 as=2.0735 ps=14.59 w=14.3 l=2
X25 opamp_0/Vd10 opamp_0/Vg1 opamp_0/Vg11 GND sky130_fd_pr__nfet_g5v0d10v5 ad=2.0735 pd=14.59 as=4.147 ps=29.18 w=14.3 l=2
X26 opamp_0/Vg11 opamp_0/Vg1 opamp_0/Vd10 GND sky130_fd_pr__nfet_g5v0d10v5 ad=2.0735 pd=14.59 as=2.0735 ps=14.59 w=14.3 l=2
X27 opamp_0/Vd10 opamp_0/Vg1 opamp_0/Vg11 GND sky130_fd_pr__nfet_g5v0d10v5 ad=2.0735 pd=14.59 as=2.0735 ps=14.59 w=14.3 l=2
X28 opamp_0/Vg11 opamp_0/Vg1 opamp_0/Vd10 GND sky130_fd_pr__nfet_g5v0d10v5 ad=2.0735 pd=14.59 as=2.0735 ps=14.59 w=14.3 l=2
X29 opamp_0/Vd10 opamp_0/Vg1 opamp_0/Vg11 GND sky130_fd_pr__nfet_g5v0d10v5 ad=2.0735 pd=14.59 as=2.0735 ps=14.59 w=14.3 l=2
X30 opamp_0/Vg11 opamp_0/Vg1 opamp_0/Vd10 GND sky130_fd_pr__nfet_g5v0d10v5 ad=2.0735 pd=14.59 as=2.0735 ps=14.59 w=14.3 l=2
X31 GND opamp_0/Vg1 opamp_0/Vd10 GND sky130_fd_pr__nfet_g5v0d10v5 ad=2.9 pd=20.58 as=2.9 ps=20.58 w=10 l=5
X32 opamp_0/Vs29 opamp_0/Vg1 opamp_0/m31_32_0/m1_21854_12984# GND sky130_fd_pr__nfet_g5v0d10v5 ad=0.9657 pd=6.95 as=0.9657 ps=6.95 w=6.66 l=2
X33 opamp_0/m31_32_0/m1_21854_12984# opamp_0/Vg1 opamp_0/Vs29 GND sky130_fd_pr__nfet_g5v0d10v5 ad=1.9314 pd=13.9 as=0.9657 ps=6.95 w=6.66 l=2
X34 opamp_0/m31_32_0/m1_21854_12984# opamp_0/Vg1 opamp_0/Vs29 GND sky130_fd_pr__nfet_g5v0d10v5 ad=0.9657 pd=6.95 as=1.9314 ps=13.9 w=6.66 l=2
X35 GND opamp_0/Vg1 opamp_0/m31_32_0/m1_21854_12984# GND sky130_fd_pr__nfet_g5v0d10v5 ad=174.72501 pd=1.25256k as=6.7628 ps=48.38 w=10 l=5
X36 opamp_0/Vd9 Vp4 opamp_0/Vd8 opamp_0/Vd8 sky130_fd_pr__pfet_g5v0d10v5 ad=6.4438 pd=45.02 as=3.2219 ps=22.51 w=22.22 l=1.5
X37 opamp_0/Vd9 Vp4 opamp_0/Vd8 opamp_0/Vd8 sky130_fd_pr__pfet_g5v0d10v5 ad=3.2219 pd=22.51 as=3.2219 ps=22.51 w=22.22 l=1.5
X38 opamp_0/Vd9 Vp4 opamp_0/Vd8 opamp_0/Vd8 sky130_fd_pr__pfet_g5v0d10v5 ad=3.2219 pd=22.51 as=3.2219 ps=22.51 w=22.22 l=1.5
X39 opamp_0/Vd9 Vp4 opamp_0/Vd8 opamp_0/Vd8 sky130_fd_pr__pfet_g5v0d10v5 ad=3.2219 pd=22.51 as=3.2219 ps=22.51 w=22.22 l=1.5
X40 opamp_0/Vd9 Vp4 opamp_0/Vd8 opamp_0/Vd8 sky130_fd_pr__pfet_g5v0d10v5 ad=3.2219 pd=22.51 as=6.4438 ps=45.02 w=22.22 l=1.5
X41 opamp_0/Vd8 Vp4 opamp_0/Vd9 opamp_0/Vd8 sky130_fd_pr__pfet_g5v0d10v5 ad=3.2219 pd=22.51 as=3.2219 ps=22.51 w=22.22 l=1.5
X42 opamp_0/Vd8 Vp4 opamp_0/Vd9 opamp_0/Vd8 sky130_fd_pr__pfet_g5v0d10v5 ad=3.2219 pd=22.51 as=3.2219 ps=22.51 w=22.22 l=1.5
X43 opamp_0/Vd8 Vp4 opamp_0/Vd9 opamp_0/Vd8 sky130_fd_pr__pfet_g5v0d10v5 ad=3.2219 pd=22.51 as=3.2219 ps=22.51 w=22.22 l=1.5
X44 opamp_0/Vd8 Vp4 opamp_0/Vd9 opamp_0/Vd8 sky130_fd_pr__pfet_g5v0d10v5 ad=3.2219 pd=22.51 as=3.2219 ps=22.51 w=22.22 l=1.5
X45 opamp_0/Vd10 Vn4 opamp_0/Vd8 opamp_0/Vd8 sky130_fd_pr__pfet_g5v0d10v5 ad=32.219 pd=225.10001 as=72.094 ps=504.16 w=22.22 l=1.5
X46 opamp_0/Vd10 Vn4 opamp_0/Vd8 opamp_0/Vd8 sky130_fd_pr__pfet_g5v0d10v5 ad=0 pd=0 as=0 ps=0 w=22.22 l=1.5
X47 opamp_0/Vd10 Vn4 opamp_0/Vd8 opamp_0/Vd8 sky130_fd_pr__pfet_g5v0d10v5 ad=0 pd=0 as=0 ps=0 w=22.22 l=1.5
X48 opamp_0/Vd10 Vn4 opamp_0/Vd8 opamp_0/Vd8 sky130_fd_pr__pfet_g5v0d10v5 ad=0 pd=0 as=0 ps=0 w=22.22 l=1.5
X49 opamp_0/Vd10 Vn4 opamp_0/Vd8 opamp_0/Vd8 sky130_fd_pr__pfet_g5v0d10v5 ad=0 pd=0 as=0 ps=0 w=22.22 l=1.5
X50 opamp_0/Vd8 Vn4 opamp_0/Vd10 opamp_0/Vd8 sky130_fd_pr__pfet_g5v0d10v5 ad=0 pd=0 as=0 ps=0 w=22.22 l=1.5
X51 opamp_0/Vd8 Vn4 opamp_0/Vd10 opamp_0/Vd8 sky130_fd_pr__pfet_g5v0d10v5 ad=0 pd=0 as=0 ps=0 w=22.22 l=1.5
X52 opamp_0/Vd8 Vn4 opamp_0/Vd10 opamp_0/Vd8 sky130_fd_pr__pfet_g5v0d10v5 ad=0 pd=0 as=0 ps=0 w=22.22 l=1.5
X53 opamp_0/Vd8 Vn4 opamp_0/Vd10 opamp_0/Vd8 sky130_fd_pr__pfet_g5v0d10v5 ad=0 pd=0 as=0 ps=0 w=22.22 l=1.5
X54 opamp_0/Vg5 opamp_0/Vg1 opamp_0/M03_04/sky130_fd_pr__nfet_g5v0d10v5_Y3KDPX_0/D GND sky130_fd_pr__nfet_g5v0d10v5 ad=0.48285 pd=3.62 as=0.48285 ps=3.62 w=3.33 l=2
X55 opamp_0/M03_04/sky130_fd_pr__nfet_g5v0d10v5_Y3KDPX_0/D opamp_0/Vg1 opamp_0/Vg5 GND sky130_fd_pr__nfet_g5v0d10v5 ad=0.9657 pd=7.24 as=0.48285 ps=3.62 w=3.33 l=2
X56 opamp_0/M03_04/sky130_fd_pr__nfet_g5v0d10v5_Y3KDPX_0/D opamp_0/Vg1 opamp_0/Vg5 GND sky130_fd_pr__nfet_g5v0d10v5 ad=0.48285 pd=3.62 as=0.9657 ps=7.24 w=3.33 l=2
X57 GND opamp_0/Vg1 opamp_0/M03_04/sky130_fd_pr__nfet_g5v0d10v5_Y3KDPX_0/D GND sky130_fd_pr__nfet_g5v0d10v5 ad=1.45 pd=10.58 as=1.45 ps=10.58 w=5 l=5
X58 Vout opamp_0/Vg27 VDD VDD sky130_fd_pr__pfet_g5v0d10v5 ad=2.175 pd=15.29 as=2.175 ps=15.29 w=15 l=0.5
X59 Vout opamp_0/Vg27 VDD VDD sky130_fd_pr__pfet_g5v0d10v5 ad=2.175 pd=15.29 as=2.175 ps=15.29 w=15 l=0.5
X60 Vout opamp_0/Vg27 VDD VDD sky130_fd_pr__pfet_g5v0d10v5 ad=2.175 pd=15.29 as=2.175 ps=15.29 w=15 l=0.5
X61 VDD opamp_0/Vg27 Vout VDD sky130_fd_pr__pfet_g5v0d10v5 ad=2.175 pd=15.29 as=2.175 ps=15.29 w=15 l=0.5
X62 Vout opamp_0/Vg27 VDD VDD sky130_fd_pr__pfet_g5v0d10v5 ad=2.175 pd=15.29 as=2.175 ps=15.29 w=15 l=0.5
X63 VDD opamp_0/Vg27 Vout VDD sky130_fd_pr__pfet_g5v0d10v5 ad=2.175 pd=15.29 as=2.175 ps=15.29 w=15 l=0.5
X64 Vout opamp_0/Vg27 VDD VDD sky130_fd_pr__pfet_g5v0d10v5 ad=2.175 pd=15.29 as=2.175 ps=15.29 w=15 l=0.5
X65 Vout opamp_0/Vg27 VDD VDD sky130_fd_pr__pfet_g5v0d10v5 ad=2.175 pd=15.29 as=2.175 ps=15.29 w=15 l=0.5
X66 Vout opamp_0/Vg27 VDD VDD sky130_fd_pr__pfet_g5v0d10v5 ad=2.175 pd=15.29 as=4.35 ps=30.58 w=15 l=0.5
X67 VDD opamp_0/Vg27 Vout VDD sky130_fd_pr__pfet_g5v0d10v5 ad=2.175 pd=15.29 as=2.175 ps=15.29 w=15 l=0.5
X68 Vout opamp_0/Vg27 VDD VDD sky130_fd_pr__pfet_g5v0d10v5 ad=2.175 pd=15.29 as=2.175 ps=15.29 w=15 l=0.5
X69 VDD opamp_0/Vg27 Vout VDD sky130_fd_pr__pfet_g5v0d10v5 ad=2.175 pd=15.29 as=2.175 ps=15.29 w=15 l=0.5
X70 VDD opamp_0/Vg27 Vout VDD sky130_fd_pr__pfet_g5v0d10v5 ad=2.175 pd=15.29 as=2.175 ps=15.29 w=15 l=0.5
X71 Vout opamp_0/Vg27 VDD VDD sky130_fd_pr__pfet_g5v0d10v5 ad=2.175 pd=15.29 as=2.175 ps=15.29 w=15 l=0.5
X72 VDD opamp_0/Vg27 Vout VDD sky130_fd_pr__pfet_g5v0d10v5 ad=2.175 pd=15.29 as=2.175 ps=15.29 w=15 l=0.5
X73 VDD opamp_0/Vg27 Vout VDD sky130_fd_pr__pfet_g5v0d10v5 ad=2.175 pd=15.29 as=2.175 ps=15.29 w=15 l=0.5
X74 Vout opamp_0/Vg27 VDD VDD sky130_fd_pr__pfet_g5v0d10v5 ad=2.175 pd=15.29 as=2.175 ps=15.29 w=15 l=0.5
X75 VDD opamp_0/Vg27 Vout VDD sky130_fd_pr__pfet_g5v0d10v5 ad=2.175 pd=15.29 as=2.175 ps=15.29 w=15 l=0.5
X76 Vout opamp_0/Vg27 VDD VDD sky130_fd_pr__pfet_g5v0d10v5 ad=2.175 pd=15.29 as=2.175 ps=15.29 w=15 l=0.5
X77 VDD opamp_0/Vg27 Vout VDD sky130_fd_pr__pfet_g5v0d10v5 ad=2.175 pd=15.29 as=2.175 ps=15.29 w=15 l=0.5
X78 Vout opamp_0/Vg27 VDD VDD sky130_fd_pr__pfet_g5v0d10v5 ad=2.175 pd=15.29 as=2.175 ps=15.29 w=15 l=0.5
X79 VDD opamp_0/Vg27 Vout VDD sky130_fd_pr__pfet_g5v0d10v5 ad=2.175 pd=15.29 as=2.175 ps=15.29 w=15 l=0.5
X80 VDD opamp_0/Vg27 Vout VDD sky130_fd_pr__pfet_g5v0d10v5 ad=2.175 pd=15.29 as=2.175 ps=15.29 w=15 l=0.5
X81 Vout opamp_0/Vg27 VDD VDD sky130_fd_pr__pfet_g5v0d10v5 ad=4.35 pd=30.58 as=2.175 ps=15.29 w=15 l=0.5
X82 VDD opamp_0/Vg27 Vout VDD sky130_fd_pr__pfet_g5v0d10v5 ad=2.175 pd=15.29 as=2.175 ps=15.29 w=15 l=0.5
X83 GND Vref opamp_0/VgR2 GND sky130_fd_pr__nfet_g5v0d10v5 ad=1.45 pd=10.58 as=1.45 ps=10.58 w=5 l=8
X84 opamp_0/VgR2 opamp_0/VgR2 VDD VDD sky130_fd_pr__pfet_g5v0d10v5 ad=1.16 pd=8.58 as=401.07001 ps=2.83676k w=4 l=5
X85 opamp_0/Vg1 opamp_0/VgR2 VDD VDD sky130_fd_pr__pfet_g5v0d10v5 ad=1.16 pd=8.58 as=0 ps=0 w=4 l=5
X86 opamp_0/Vd9 opamp_0/Vg1 opamp_0/Vg28 GND sky130_fd_pr__nfet_g5v0d10v5 ad=19.488 pd=137.3 as=25.288 ps=178.46001 w=14.3 l=2
X87 opamp_0/Vd9 opamp_0/Vg1 opamp_0/Vg28 GND sky130_fd_pr__nfet_g5v0d10v5 ad=0 pd=0 as=0 ps=0 w=14.3 l=2
X88 opamp_0/Vg28 opamp_0/Vg1 opamp_0/Vd9 GND sky130_fd_pr__nfet_g5v0d10v5 ad=0 pd=0 as=0 ps=0 w=14.3 l=2
X89 opamp_0/Vd9 opamp_0/Vg1 opamp_0/Vg28 GND sky130_fd_pr__nfet_g5v0d10v5 ad=0 pd=0 as=0 ps=0 w=14.3 l=2
X90 opamp_0/Vg28 opamp_0/Vg1 opamp_0/Vd9 GND sky130_fd_pr__nfet_g5v0d10v5 ad=0 pd=0 as=0 ps=0 w=14.3 l=2
X91 opamp_0/Vd9 opamp_0/Vg1 opamp_0/Vg28 GND sky130_fd_pr__nfet_g5v0d10v5 ad=0 pd=0 as=0 ps=0 w=14.3 l=2
X92 opamp_0/Vg28 opamp_0/Vg1 opamp_0/Vd9 GND sky130_fd_pr__nfet_g5v0d10v5 ad=0 pd=0 as=0 ps=0 w=14.3 l=2
X93 GND opamp_0/Vg1 opamp_0/Vd9 GND sky130_fd_pr__nfet_g5v0d10v5 ad=0 pd=0 as=0 ps=0 w=10 l=5
X94 opamp_0/m25_26_0/m1_160_1028# opamp_0/m25_26_0/m1_160_1028# GND GND sky130_fd_pr__nfet_g5v0d10v5 ad=0.725 pd=5.29 as=0.725 ps=5.29 w=5 l=0.5
X95 opamp_0/m25_26_0/m1_160_1028# opamp_0/m25_26_0/m1_160_1028# GND GND sky130_fd_pr__nfet_g5v0d10v5 ad=0.725 pd=5.29 as=0.725 ps=5.29 w=5 l=0.5
X96 GND opamp_0/m25_26_0/m1_160_1028# opamp_0/m25_26_0/m1_160_1028# GND sky130_fd_pr__nfet_g5v0d10v5 ad=0.725 pd=5.29 as=1.45 ps=10.58 w=5 l=0.5
X97 GND opamp_0/m25_26_0/m1_160_1028# opamp_0/m25_26_0/m1_160_1028# GND sky130_fd_pr__nfet_g5v0d10v5 ad=1.45 pd=10.58 as=0.725 ps=5.29 w=5 l=0.5
X98 GND opamp_0/m25_26_0/m1_160_1028# opamp_0/m25_26_0/m1_160_1028# GND sky130_fd_pr__nfet_g5v0d10v5 ad=0.725 pd=5.29 as=0.725 ps=5.29 w=5 l=0.5
X99 opamp_0/Vd24 opamp_0/Vd24 opamp_0/m25_26_0/m1_160_1028# GND sky130_fd_pr__nfet_g5v0d10v5 ad=4.35 pd=31.74 as=8.7 ps=63.48 w=5 l=0.5
X100 opamp_0/Vd24 opamp_0/Vd24 opamp_0/m25_26_0/m1_160_1028# GND sky130_fd_pr__nfet_g5v0d10v5 ad=0 pd=0 as=0 ps=0 w=5 l=0.5
X101 opamp_0/m25_26_0/m1_160_1028# opamp_0/Vd24 opamp_0/Vd24 GND sky130_fd_pr__nfet_g5v0d10v5 ad=0 pd=0 as=0 ps=0 w=5 l=0.5
X102 opamp_0/m25_26_0/m1_160_1028# opamp_0/Vd24 opamp_0/Vd24 GND sky130_fd_pr__nfet_g5v0d10v5 ad=0 pd=0 as=0 ps=0 w=5 l=0.5
X103 opamp_0/m25_26_0/m1_160_1028# opamp_0/Vd24 opamp_0/Vd24 GND sky130_fd_pr__nfet_g5v0d10v5 ad=0 pd=0 as=0 ps=0 w=5 l=0.5
X104 opamp_0/Vg28 opamp_0/Vd24 opamp_0/Vg27 GND sky130_fd_pr__nfet_g5v0d10v5 ad=1.45 pd=10.29 as=2.9 ps=20.58 w=10 l=0.5
X105 opamp_0/Vg28 opamp_0/Vd24 opamp_0/Vg27 GND sky130_fd_pr__nfet_g5v0d10v5 ad=2.9 pd=20.58 as=1.45 ps=10.29 w=10 l=0.5
X106 opamp_0/Vg28 opamp_0/Vd24 opamp_0/Vg27 GND sky130_fd_pr__nfet_g5v0d10v5 ad=1.45 pd=10.29 as=1.45 ps=10.29 w=10 l=0.5
X107 opamp_0/Vg27 opamp_0/Vd24 opamp_0/Vg28 GND sky130_fd_pr__nfet_g5v0d10v5 ad=1.45 pd=10.29 as=1.45 ps=10.29 w=10 l=0.5
X108 opamp_0/Vg27 opamp_0/Vd24 opamp_0/Vg28 GND sky130_fd_pr__nfet_g5v0d10v5 ad=1.45 pd=10.29 as=1.45 ps=10.29 w=10 l=0.5
X109 opamp_0/Vg11 opamp_0/Vg11 opamp_0/Vd30 VDD sky130_fd_pr__pfet_g5v0d10v5 ad=8.7 pd=61.74 as=17.4 ps=123.48 w=10 l=1
X110 opamp_0/Vd30 opamp_0/Vg11 opamp_0/Vg11 VDD sky130_fd_pr__pfet_g5v0d10v5 ad=0 pd=0 as=0 ps=0 w=10 l=1
X111 opamp_0/Vd30 opamp_0/Vg11 opamp_0/Vg11 VDD sky130_fd_pr__pfet_g5v0d10v5 ad=0 pd=0 as=0 ps=0 w=10 l=1
X112 opamp_0/Vg11 opamp_0/Vg11 opamp_0/Vd30 VDD sky130_fd_pr__pfet_g5v0d10v5 ad=0 pd=0 as=0 ps=0 w=10 l=1
X113 opamp_0/Vg11 opamp_0/Vg11 opamp_0/Vd30 VDD sky130_fd_pr__pfet_g5v0d10v5 ad=0 pd=0 as=0 ps=0 w=10 l=1
X114 opamp_0/Vd30 opamp_0/Vg11 VDD VDD sky130_fd_pr__pfet_g5v0d10v5 ad=0 pd=0 as=0 ps=0 w=10 l=2.5
X115 VDD opamp_0/Vg11 opamp_0/Vd30 VDD sky130_fd_pr__pfet_g5v0d10v5 ad=0 pd=0 as=0 ps=0 w=10 l=2.5
X116 VDD opamp_0/Vg11 opamp_0/Vd30 VDD sky130_fd_pr__pfet_g5v0d10v5 ad=0 pd=0 as=0 ps=0 w=10 l=2.5
X117 opamp_0/Vd30 opamp_0/Vg11 VDD VDD sky130_fd_pr__pfet_g5v0d10v5 ad=0 pd=0 as=0 ps=0 w=10 l=2.5
X118 opamp_0/Vd30 opamp_0/Vg11 VDD VDD sky130_fd_pr__pfet_g5v0d10v5 ad=0 pd=0 as=0 ps=0 w=10 l=2.5
X119 opamp_0/Vg27 Vout sky130_fd_pr__cap_mim_m3_1 l=20 w=30
X120 opamp_0/Vg27 Vout sky130_fd_pr__cap_mim_m3_1 l=20 w=30
X121 opamp_0/Vg27 Vout sky130_fd_pr__cap_mim_m3_1 l=20 w=30
X122 opamp_0/Vg27 Vout sky130_fd_pr__cap_mim_m3_1 l=20 w=30
X123 opamp_0/Vg28 Vout sky130_fd_pr__cap_mim_m3_1 l=20 w=30
X124 opamp_0/Vg28 Vout sky130_fd_pr__cap_mim_m3_1 l=20 w=30
X125 opamp_0/Vg28 Vout sky130_fd_pr__cap_mim_m3_1 l=20 w=30
X126 opamp_0/Vg28 Vout sky130_fd_pr__cap_mim_m3_1 l=20 w=30
X127 opamp_0/Vg1 opamp_0/Vg1 opamp_0/m01_02/sky130_fd_pr__nfet_g5v0d10v5_Y3KDPX_0/D GND sky130_fd_pr__nfet_g5v0d10v5 ad=1.9314 pd=14.48 as=3.3814 ps=25.06 w=3.33 l=2
X128 opamp_0/m01_02/sky130_fd_pr__nfet_g5v0d10v5_Y3KDPX_0/D opamp_0/Vg1 opamp_0/Vg1 GND sky130_fd_pr__nfet_g5v0d10v5 ad=0 pd=0 as=0 ps=0 w=3.33 l=2
X129 opamp_0/m01_02/sky130_fd_pr__nfet_g5v0d10v5_Y3KDPX_0/D opamp_0/Vg1 opamp_0/Vg1 GND sky130_fd_pr__nfet_g5v0d10v5 ad=0 pd=0 as=0 ps=0 w=3.33 l=2
X130 GND opamp_0/Vg1 opamp_0/m01_02/sky130_fd_pr__nfet_g5v0d10v5_Y3KDPX_0/D GND sky130_fd_pr__nfet_g5v0d10v5 ad=0 pd=0 as=0 ps=0 w=5 l=5
X131 Vout opamp_0/Vg28 GND GND sky130_fd_pr__nfet_g5v0d10v5 ad=1.45 pd=10.29 as=1.45 ps=10.29 w=10 l=0.5
X132 Vout opamp_0/Vg28 GND GND sky130_fd_pr__nfet_g5v0d10v5 ad=1.45 pd=10.29 as=1.45 ps=10.29 w=10 l=0.5
X133 GND opamp_0/Vg28 Vout GND sky130_fd_pr__nfet_g5v0d10v5 ad=1.45 pd=10.29 as=1.45 ps=10.29 w=10 l=0.5
X134 Vout opamp_0/Vg28 GND GND sky130_fd_pr__nfet_g5v0d10v5 ad=1.45 pd=10.29 as=1.45 ps=10.29 w=10 l=0.5
X135 Vout opamp_0/Vg28 GND GND sky130_fd_pr__nfet_g5v0d10v5 ad=1.45 pd=10.29 as=1.45 ps=10.29 w=10 l=0.5
X136 Vout opamp_0/Vg28 GND GND sky130_fd_pr__nfet_g5v0d10v5 ad=1.45 pd=10.29 as=1.45 ps=10.29 w=10 l=0.5
X137 GND opamp_0/Vg28 Vout GND sky130_fd_pr__nfet_g5v0d10v5 ad=1.45 pd=10.29 as=1.45 ps=10.29 w=10 l=0.5
X138 Vout opamp_0/Vg28 GND GND sky130_fd_pr__nfet_g5v0d10v5 ad=1.45 pd=10.29 as=1.45 ps=10.29 w=10 l=0.5
X139 GND opamp_0/Vg28 Vout GND sky130_fd_pr__nfet_g5v0d10v5 ad=1.45 pd=10.29 as=1.45 ps=10.29 w=10 l=0.5
X140 GND opamp_0/Vg28 Vout GND sky130_fd_pr__nfet_g5v0d10v5 ad=1.45 pd=10.29 as=2.9 ps=20.58 w=10 l=0.5
X141 GND opamp_0/Vg28 Vout GND sky130_fd_pr__nfet_g5v0d10v5 ad=2.9 pd=20.58 as=1.45 ps=10.29 w=10 l=0.5
X142 GND opamp_0/Vg28 Vout GND sky130_fd_pr__nfet_g5v0d10v5 ad=1.45 pd=10.29 as=1.45 ps=10.29 w=10 l=0.5
X143 GND opamp_0/Vg28 Vout GND sky130_fd_pr__nfet_g5v0d10v5 ad=1.45 pd=10.29 as=1.45 ps=10.29 w=10 l=0.5
X144 GND opamp_0/Vg28 Vout GND sky130_fd_pr__nfet_g5v0d10v5 ad=1.45 pd=10.29 as=1.45 ps=10.29 w=10 l=0.5
X145 Vout opamp_0/Vg28 GND GND sky130_fd_pr__nfet_g5v0d10v5 ad=1.45 pd=10.29 as=1.45 ps=10.29 w=10 l=0.5
X146 opamp_0/Vs29 Vp4 opamp_0/Vd29 GND sky130_fd_pr__nfet_g5v0d10v5 ad=1.61095 pd=11.4 as=1.61095 ps=11.4 w=11.11 l=1.5
X147 opamp_0/Vs29 Vp4 opamp_0/Vd29 GND sky130_fd_pr__nfet_g5v0d10v5 ad=1.61095 pd=11.4 as=1.61095 ps=11.4 w=11.11 l=1.5
X148 opamp_0/Vs29 Vp4 opamp_0/Vd29 GND sky130_fd_pr__nfet_g5v0d10v5 ad=1.61095 pd=11.4 as=3.2219 ps=22.8 w=11.11 l=1.5
X149 opamp_0/Vd29 Vp4 opamp_0/Vs29 GND sky130_fd_pr__nfet_g5v0d10v5 ad=1.61095 pd=11.4 as=1.61095 ps=11.4 w=11.11 l=1.5
X150 opamp_0/Vd29 Vp4 opamp_0/Vs29 GND sky130_fd_pr__nfet_g5v0d10v5 ad=1.61095 pd=11.4 as=1.61095 ps=11.4 w=11.11 l=1.5
X151 opamp_0/Vd29 Vp4 opamp_0/Vs29 GND sky130_fd_pr__nfet_g5v0d10v5 ad=1.61095 pd=11.4 as=1.61095 ps=11.4 w=11.11 l=1.5
X152 opamp_0/Vd29 Vp4 opamp_0/Vs29 GND sky130_fd_pr__nfet_g5v0d10v5 ad=1.61095 pd=11.4 as=1.61095 ps=11.4 w=11.11 l=1.5
X153 opamp_0/Vs29 Vp4 opamp_0/Vd29 GND sky130_fd_pr__nfet_g5v0d10v5 ad=3.2219 pd=22.8 as=1.61095 ps=11.4 w=11.11 l=1.5
X154 opamp_0/Vs29 Vp4 opamp_0/Vd29 GND sky130_fd_pr__nfet_g5v0d10v5 ad=1.61095 pd=11.4 as=1.61095 ps=11.4 w=11.11 l=1.5
X155 opamp_0/Vs29 Vn4 opamp_0/Vd30 GND sky130_fd_pr__nfet_g5v0d10v5 ad=36.0818 pd=255.8 as=16.1095 ps=114 w=11.11 l=1.5
X156 opamp_0/Vs29 Vn4 opamp_0/Vd30 GND sky130_fd_pr__nfet_g5v0d10v5 ad=0 pd=0 as=0 ps=0 w=11.11 l=1.5
X157 opamp_0/Vs29 Vn4 opamp_0/Vd30 GND sky130_fd_pr__nfet_g5v0d10v5 ad=0 pd=0 as=0 ps=0 w=11.11 l=1.5
X158 opamp_0/Vd30 Vn4 opamp_0/Vs29 GND sky130_fd_pr__nfet_g5v0d10v5 ad=0 pd=0 as=0 ps=0 w=11.11 l=1.5
X159 opamp_0/Vd30 Vn4 opamp_0/Vs29 GND sky130_fd_pr__nfet_g5v0d10v5 ad=0 pd=0 as=0 ps=0 w=11.11 l=1.5
X160 opamp_0/Vd30 Vn4 opamp_0/Vs29 GND sky130_fd_pr__nfet_g5v0d10v5 ad=0 pd=0 as=0 ps=0 w=11.11 l=1.5
X161 opamp_0/Vd30 Vn4 opamp_0/Vs29 GND sky130_fd_pr__nfet_g5v0d10v5 ad=0 pd=0 as=0 ps=0 w=11.11 l=1.5
X162 opamp_0/Vs29 Vn4 opamp_0/Vd30 GND sky130_fd_pr__nfet_g5v0d10v5 ad=0 pd=0 as=0 ps=0 w=11.11 l=1.5
X163 opamp_0/Vs29 Vn4 opamp_0/Vd30 GND sky130_fd_pr__nfet_g5v0d10v5 ad=0 pd=0 as=0 ps=0 w=11.11 l=1.5
X164 VDD opamp_0/m21_22_0/G opamp_0/m21_22_0/G VDD sky130_fd_pr__pfet_g5v0d10v5 ad=4.35 pd=30.58 as=2.175 ps=15.29 w=15 l=0.5
X165 VDD opamp_0/m21_22_0/G opamp_0/m21_22_0/G VDD sky130_fd_pr__pfet_g5v0d10v5 ad=2.175 pd=15.29 as=2.175 ps=15.29 w=15 l=0.5
X166 opamp_0/m21_22_0/G opamp_0/m21_22_0/G VDD VDD sky130_fd_pr__pfet_g5v0d10v5 ad=2.175 pd=15.29 as=2.175 ps=15.29 w=15 l=0.5
X167 VDD opamp_0/m21_22_0/G opamp_0/m21_22_0/G VDD sky130_fd_pr__pfet_g5v0d10v5 ad=2.175 pd=15.29 as=4.35 ps=30.58 w=15 l=0.5
X168 opamp_0/m21_22_0/G opamp_0/m21_22_0/G VDD VDD sky130_fd_pr__pfet_g5v0d10v5 ad=2.175 pd=15.29 as=2.175 ps=15.29 w=15 l=0.5
X169 opamp_0/m21_22_0/G opamp_0/Vg22 opamp_0/Vg22 VDD sky130_fd_pr__pfet_g5v0d10v5 ad=26.1 pd=183.48 as=13.05 ps=91.74 w=15 l=0.5
X170 opamp_0/m21_22_0/G opamp_0/Vg22 opamp_0/Vg22 VDD sky130_fd_pr__pfet_g5v0d10v5 ad=0 pd=0 as=0 ps=0 w=15 l=0.5
X171 opamp_0/Vg22 opamp_0/Vg22 opamp_0/m21_22_0/G VDD sky130_fd_pr__pfet_g5v0d10v5 ad=0 pd=0 as=0 ps=0 w=15 l=0.5
X172 opamp_0/m21_22_0/G opamp_0/Vg22 opamp_0/Vg22 VDD sky130_fd_pr__pfet_g5v0d10v5 ad=0 pd=0 as=0 ps=0 w=15 l=0.5
X173 opamp_0/Vg22 opamp_0/Vg22 opamp_0/m21_22_0/G VDD sky130_fd_pr__pfet_g5v0d10v5 ad=0 pd=0 as=0 ps=0 w=15 l=0.5
X174 opamp_0/Vg27 opamp_0/Vg22 opamp_0/Vg28 VDD sky130_fd_pr__pfet_g5v0d10v5 ad=1.45 pd=10.29 as=1.45 ps=10.29 w=10 l=0.5
X175 opamp_0/Vg27 opamp_0/Vg22 opamp_0/Vg28 VDD sky130_fd_pr__pfet_g5v0d10v5 ad=1.45 pd=10.29 as=1.45 ps=10.29 w=10 l=0.5
X176 opamp_0/Vg27 opamp_0/Vg22 opamp_0/Vg28 VDD sky130_fd_pr__pfet_g5v0d10v5 ad=1.45 pd=10.29 as=1.45 ps=10.29 w=10 l=0.5
X177 opamp_0/Vg28 opamp_0/Vg22 opamp_0/Vg27 VDD sky130_fd_pr__pfet_g5v0d10v5 ad=1.45 pd=10.29 as=1.45 ps=10.29 w=10 l=0.5
X178 opamp_0/Vg27 opamp_0/Vg22 opamp_0/Vg28 VDD sky130_fd_pr__pfet_g5v0d10v5 ad=1.45 pd=10.29 as=1.45 ps=10.29 w=10 l=0.5
X179 opamp_0/Vg27 opamp_0/Vg22 opamp_0/Vg28 VDD sky130_fd_pr__pfet_g5v0d10v5 ad=1.45 pd=10.29 as=1.45 ps=10.29 w=10 l=0.5
X180 opamp_0/Vg27 opamp_0/Vg22 opamp_0/Vg28 VDD sky130_fd_pr__pfet_g5v0d10v5 ad=1.45 pd=10.29 as=1.45 ps=10.29 w=10 l=0.5
X181 opamp_0/Vg28 opamp_0/Vg22 opamp_0/Vg27 VDD sky130_fd_pr__pfet_g5v0d10v5 ad=1.45 pd=10.29 as=1.45 ps=10.29 w=10 l=0.5
X182 opamp_0/Vg27 opamp_0/Vg22 opamp_0/Vg28 VDD sky130_fd_pr__pfet_g5v0d10v5 ad=1.45 pd=10.29 as=1.45 ps=10.29 w=10 l=0.5
X183 opamp_0/Vg28 opamp_0/Vg22 opamp_0/Vg27 VDD sky130_fd_pr__pfet_g5v0d10v5 ad=1.45 pd=10.29 as=1.45 ps=10.29 w=10 l=0.5
X184 opamp_0/Vg28 opamp_0/Vg22 opamp_0/Vg27 VDD sky130_fd_pr__pfet_g5v0d10v5 ad=1.45 pd=10.29 as=2.9 ps=20.58 w=10 l=0.5
X185 opamp_0/Vg28 opamp_0/Vg22 opamp_0/Vg27 VDD sky130_fd_pr__pfet_g5v0d10v5 ad=2.9 pd=20.58 as=1.45 ps=10.29 w=10 l=0.5
X186 opamp_0/Vg28 opamp_0/Vg22 opamp_0/Vg27 VDD sky130_fd_pr__pfet_g5v0d10v5 ad=1.45 pd=10.29 as=1.45 ps=10.29 w=10 l=0.5
X187 opamp_0/Vg28 opamp_0/Vg22 opamp_0/Vg27 VDD sky130_fd_pr__pfet_g5v0d10v5 ad=1.45 pd=10.29 as=1.45 ps=10.29 w=10 l=0.5
X188 opamp_0/Vg28 opamp_0/Vg22 opamp_0/Vg27 VDD sky130_fd_pr__pfet_g5v0d10v5 ad=1.45 pd=10.29 as=1.45 ps=10.29 w=10 l=0.5
X189 opamp_0/m5_m6_0/m1_4014_7500# opamp_0/Vg5 VDD VDD sky130_fd_pr__pfet_g5v0d10v5 ad=1.45 pd=10.58 as=0.725 ps=5.29 w=5 l=5
X190 VDD opamp_0/Vg5 opamp_0/m5_m6_0/m1_4014_7500# VDD sky130_fd_pr__pfet_g5v0d10v5 ad=0.725 pd=5.29 as=0.725 ps=5.29 w=5 l=5
X191 opamp_0/m5_m6_0/m1_4014_7500# opamp_0/Vg5 VDD VDD sky130_fd_pr__pfet_g5v0d10v5 ad=0.725 pd=5.29 as=1.45 ps=10.58 w=5 l=5
X192 opamp_0/m5_m6_0/m1_4014_7500# opamp_0/Vg5 opamp_0/Vg5 VDD sky130_fd_pr__pfet_g5v0d10v5 ad=0.957 pd=6.89 as=0.957 ps=6.89 w=6.6 l=2
X193 opamp_0/Vg5 opamp_0/Vg5 opamp_0/m5_m6_0/m1_4014_7500# VDD sky130_fd_pr__pfet_g5v0d10v5 ad=1.914 pd=13.78 as=0.957 ps=6.89 w=6.6 l=2
X194 opamp_0/Vg5 opamp_0/Vg5 opamp_0/m5_m6_0/m1_4014_7500# VDD sky130_fd_pr__pfet_g5v0d10v5 ad=0.957 pd=6.89 as=1.914 ps=13.78 w=6.6 l=2
X195 opamp_1/Vg27 opamp_1/Vg11 opamp_1/Vd29 VDD sky130_fd_pr__pfet_g5v0d10v5 ad=31.9 pd=226.38 as=17.4 ps=123.48 w=10 l=1
X196 opamp_1/Vd29 opamp_1/Vg11 opamp_1/Vg27 VDD sky130_fd_pr__pfet_g5v0d10v5 ad=0 pd=0 as=0 ps=0 w=10 l=1
X197 opamp_1/Vd29 opamp_1/Vg11 opamp_1/Vg27 VDD sky130_fd_pr__pfet_g5v0d10v5 ad=0 pd=0 as=0 ps=0 w=10 l=1
X198 opamp_1/Vg27 opamp_1/Vg11 opamp_1/Vd29 VDD sky130_fd_pr__pfet_g5v0d10v5 ad=0 pd=0 as=0 ps=0 w=10 l=1
X199 opamp_1/Vg27 opamp_1/Vg11 opamp_1/Vd29 VDD sky130_fd_pr__pfet_g5v0d10v5 ad=0 pd=0 as=0 ps=0 w=10 l=1
X200 opamp_1/Vd29 opamp_1/Vg11 VDD VDD sky130_fd_pr__pfet_g5v0d10v5 ad=0 pd=0 as=0 ps=0 w=10 l=2.5
X201 VDD opamp_1/Vg11 opamp_1/Vd29 VDD sky130_fd_pr__pfet_g5v0d10v5 ad=0 pd=0 as=0 ps=0 w=10 l=2.5
X202 VDD opamp_1/Vg11 opamp_1/Vd29 VDD sky130_fd_pr__pfet_g5v0d10v5 ad=0 pd=0 as=0 ps=0 w=10 l=2.5
X203 opamp_1/Vd29 opamp_1/Vg11 VDD VDD sky130_fd_pr__pfet_g5v0d10v5 ad=0 pd=0 as=0 ps=0 w=10 l=2.5
X204 opamp_1/Vd29 opamp_1/Vg11 VDD VDD sky130_fd_pr__pfet_g5v0d10v5 ad=0 pd=0 as=0 ps=0 w=10 l=2.5
X205 GND opamp_1/Vg1 opamp_1/Vg22 GND sky130_fd_pr__nfet_g5v0d10v5 ad=0 pd=0 as=0.435 ps=3.58 w=1.5 l=5
X206 opamp_1/Vd24 opamp_1/Vg5 VDD VDD sky130_fd_pr__pfet_g5v0d10v5 ad=1.16 pd=8.58 as=0 ps=0 w=4 l=5
X207 opamp_1/m07_08_0/m1_29362_10250# opamp_1/Vg5 opamp_1/Vd8 VDD sky130_fd_pr__pfet_g5v0d10v5 ad=13.456 pd=95.12 as=72.094 ps=504.16 w=13.2 l=2
X208 opamp_1/Vd8 opamp_1/Vg5 opamp_1/m07_08_0/m1_29362_10250# VDD sky130_fd_pr__pfet_g5v0d10v5 ad=0 pd=0 as=0 ps=0 w=13.2 l=2
X209 opamp_1/Vd8 opamp_1/Vg5 opamp_1/m07_08_0/m1_29362_10250# VDD sky130_fd_pr__pfet_g5v0d10v5 ad=0 pd=0 as=0 ps=0 w=13.2 l=2
X210 VDD opamp_1/Vg5 opamp_1/m07_08_0/m1_29362_10250# VDD sky130_fd_pr__pfet_g5v0d10v5 ad=0 pd=0 as=0 ps=0 w=10 l=5
X211 opamp_1/m07_08_0/m1_29362_10250# opamp_1/Vg5 VDD VDD sky130_fd_pr__pfet_g5v0d10v5 ad=0 pd=0 as=0 ps=0 w=10 l=5
X212 opamp_1/m07_08_0/m1_29362_10250# opamp_1/Vg5 VDD VDD sky130_fd_pr__pfet_g5v0d10v5 ad=0 pd=0 as=0 ps=0 w=10 l=5
X213 opamp_1/Vd10 opamp_1/Vg1 opamp_1/Vg11 GND sky130_fd_pr__nfet_g5v0d10v5 ad=19.488 pd=137.3 as=16.588 ps=116.72 w=14.3 l=2
X214 opamp_1/Vd10 opamp_1/Vg1 opamp_1/Vg11 GND sky130_fd_pr__nfet_g5v0d10v5 ad=0 pd=0 as=0 ps=0 w=14.3 l=2
X215 opamp_1/Vg11 opamp_1/Vg1 opamp_1/Vd10 GND sky130_fd_pr__nfet_g5v0d10v5 ad=0 pd=0 as=0 ps=0 w=14.3 l=2
X216 opamp_1/Vd10 opamp_1/Vg1 opamp_1/Vg11 GND sky130_fd_pr__nfet_g5v0d10v5 ad=0 pd=0 as=0 ps=0 w=14.3 l=2
X217 opamp_1/Vg11 opamp_1/Vg1 opamp_1/Vd10 GND sky130_fd_pr__nfet_g5v0d10v5 ad=0 pd=0 as=0 ps=0 w=14.3 l=2
X218 opamp_1/Vd10 opamp_1/Vg1 opamp_1/Vg11 GND sky130_fd_pr__nfet_g5v0d10v5 ad=0 pd=0 as=0 ps=0 w=14.3 l=2
X219 opamp_1/Vg11 opamp_1/Vg1 opamp_1/Vd10 GND sky130_fd_pr__nfet_g5v0d10v5 ad=0 pd=0 as=0 ps=0 w=14.3 l=2
X220 GND opamp_1/Vg1 opamp_1/Vd10 GND sky130_fd_pr__nfet_g5v0d10v5 ad=0 pd=0 as=0 ps=0 w=10 l=5
X221 opamp_1/Vs29 opamp_1/Vg1 opamp_1/m31_32_0/m1_21854_12984# GND sky130_fd_pr__nfet_g5v0d10v5 ad=36.0818 pd=255.8 as=6.7628 ps=48.38 w=6.66 l=2
X222 opamp_1/m31_32_0/m1_21854_12984# opamp_1/Vg1 opamp_1/Vs29 GND sky130_fd_pr__nfet_g5v0d10v5 ad=0 pd=0 as=0 ps=0 w=6.66 l=2
X223 opamp_1/m31_32_0/m1_21854_12984# opamp_1/Vg1 opamp_1/Vs29 GND sky130_fd_pr__nfet_g5v0d10v5 ad=0 pd=0 as=0 ps=0 w=6.66 l=2
X224 GND opamp_1/Vg1 opamp_1/m31_32_0/m1_21854_12984# GND sky130_fd_pr__nfet_g5v0d10v5 ad=0 pd=0 as=0 ps=0 w=10 l=5
X225 opamp_1/Vd9 Vn opamp_1/Vd8 opamp_1/Vd8 sky130_fd_pr__pfet_g5v0d10v5 ad=32.219 pd=225.10001 as=0 ps=0 w=22.22 l=1.5
X226 opamp_1/Vd9 Vn opamp_1/Vd8 opamp_1/Vd8 sky130_fd_pr__pfet_g5v0d10v5 ad=0 pd=0 as=0 ps=0 w=22.22 l=1.5
X227 opamp_1/Vd9 Vn opamp_1/Vd8 opamp_1/Vd8 sky130_fd_pr__pfet_g5v0d10v5 ad=0 pd=0 as=0 ps=0 w=22.22 l=1.5
X228 opamp_1/Vd9 Vn opamp_1/Vd8 opamp_1/Vd8 sky130_fd_pr__pfet_g5v0d10v5 ad=0 pd=0 as=0 ps=0 w=22.22 l=1.5
X229 opamp_1/Vd9 Vn opamp_1/Vd8 opamp_1/Vd8 sky130_fd_pr__pfet_g5v0d10v5 ad=0 pd=0 as=0 ps=0 w=22.22 l=1.5
X230 opamp_1/Vd8 Vn opamp_1/Vd9 opamp_1/Vd8 sky130_fd_pr__pfet_g5v0d10v5 ad=0 pd=0 as=0 ps=0 w=22.22 l=1.5
X231 opamp_1/Vd8 Vn opamp_1/Vd9 opamp_1/Vd8 sky130_fd_pr__pfet_g5v0d10v5 ad=0 pd=0 as=0 ps=0 w=22.22 l=1.5
X232 opamp_1/Vd8 Vn opamp_1/Vd9 opamp_1/Vd8 sky130_fd_pr__pfet_g5v0d10v5 ad=0 pd=0 as=0 ps=0 w=22.22 l=1.5
X233 opamp_1/Vd8 Vn opamp_1/Vd9 opamp_1/Vd8 sky130_fd_pr__pfet_g5v0d10v5 ad=0 pd=0 as=0 ps=0 w=22.22 l=1.5
X234 opamp_1/Vd10 Rgn opamp_1/Vd8 opamp_1/Vd8 sky130_fd_pr__pfet_g5v0d10v5 ad=32.219 pd=225.10001 as=0 ps=0 w=22.22 l=1.5
X235 opamp_1/Vd10 Rgn opamp_1/Vd8 opamp_1/Vd8 sky130_fd_pr__pfet_g5v0d10v5 ad=0 pd=0 as=0 ps=0 w=22.22 l=1.5
X236 opamp_1/Vd10 Rgn opamp_1/Vd8 opamp_1/Vd8 sky130_fd_pr__pfet_g5v0d10v5 ad=0 pd=0 as=0 ps=0 w=22.22 l=1.5
X237 opamp_1/Vd10 Rgn opamp_1/Vd8 opamp_1/Vd8 sky130_fd_pr__pfet_g5v0d10v5 ad=0 pd=0 as=0 ps=0 w=22.22 l=1.5
X238 opamp_1/Vd10 Rgn opamp_1/Vd8 opamp_1/Vd8 sky130_fd_pr__pfet_g5v0d10v5 ad=0 pd=0 as=0 ps=0 w=22.22 l=1.5
X239 opamp_1/Vd8 Rgn opamp_1/Vd10 opamp_1/Vd8 sky130_fd_pr__pfet_g5v0d10v5 ad=0 pd=0 as=0 ps=0 w=22.22 l=1.5
X240 opamp_1/Vd8 Rgn opamp_1/Vd10 opamp_1/Vd8 sky130_fd_pr__pfet_g5v0d10v5 ad=0 pd=0 as=0 ps=0 w=22.22 l=1.5
X241 opamp_1/Vd8 Rgn opamp_1/Vd10 opamp_1/Vd8 sky130_fd_pr__pfet_g5v0d10v5 ad=0 pd=0 as=0 ps=0 w=22.22 l=1.5
X242 opamp_1/Vd8 Rgn opamp_1/Vd10 opamp_1/Vd8 sky130_fd_pr__pfet_g5v0d10v5 ad=0 pd=0 as=0 ps=0 w=22.22 l=1.5
X243 opamp_1/Vg5 opamp_1/Vg1 opamp_1/M03_04/sky130_fd_pr__nfet_g5v0d10v5_Y3KDPX_0/D GND sky130_fd_pr__nfet_g5v0d10v5 ad=1.9314 pd=14.48 as=3.3814 ps=25.06 w=3.33 l=2
X244 opamp_1/M03_04/sky130_fd_pr__nfet_g5v0d10v5_Y3KDPX_0/D opamp_1/Vg1 opamp_1/Vg5 GND sky130_fd_pr__nfet_g5v0d10v5 ad=0 pd=0 as=0 ps=0 w=3.33 l=2
X245 opamp_1/M03_04/sky130_fd_pr__nfet_g5v0d10v5_Y3KDPX_0/D opamp_1/Vg1 opamp_1/Vg5 GND sky130_fd_pr__nfet_g5v0d10v5 ad=0 pd=0 as=0 ps=0 w=3.33 l=2
X246 GND opamp_1/Vg1 opamp_1/M03_04/sky130_fd_pr__nfet_g5v0d10v5_Y3KDPX_0/D GND sky130_fd_pr__nfet_g5v0d10v5 ad=0 pd=0 as=0 ps=0 w=5 l=5
X247 Vout2 opamp_1/Vg27 VDD VDD sky130_fd_pr__pfet_g5v0d10v5 ad=56.55 pd=397.54001 as=0 ps=0 w=15 l=0.5
X248 Vout2 opamp_1/Vg27 VDD VDD sky130_fd_pr__pfet_g5v0d10v5 ad=0 pd=0 as=0 ps=0 w=15 l=0.5
X249 Vout2 opamp_1/Vg27 VDD VDD sky130_fd_pr__pfet_g5v0d10v5 ad=0 pd=0 as=0 ps=0 w=15 l=0.5
X250 VDD opamp_1/Vg27 Vout2 VDD sky130_fd_pr__pfet_g5v0d10v5 ad=0 pd=0 as=0 ps=0 w=15 l=0.5
X251 Vout2 opamp_1/Vg27 VDD VDD sky130_fd_pr__pfet_g5v0d10v5 ad=0 pd=0 as=0 ps=0 w=15 l=0.5
X252 VDD opamp_1/Vg27 Vout2 VDD sky130_fd_pr__pfet_g5v0d10v5 ad=0 pd=0 as=0 ps=0 w=15 l=0.5
X253 Vout2 opamp_1/Vg27 VDD VDD sky130_fd_pr__pfet_g5v0d10v5 ad=0 pd=0 as=0 ps=0 w=15 l=0.5
X254 Vout2 opamp_1/Vg27 VDD VDD sky130_fd_pr__pfet_g5v0d10v5 ad=0 pd=0 as=0 ps=0 w=15 l=0.5
X255 Vout2 opamp_1/Vg27 VDD VDD sky130_fd_pr__pfet_g5v0d10v5 ad=0 pd=0 as=0 ps=0 w=15 l=0.5
X256 VDD opamp_1/Vg27 Vout2 VDD sky130_fd_pr__pfet_g5v0d10v5 ad=0 pd=0 as=0 ps=0 w=15 l=0.5
X257 Vout2 opamp_1/Vg27 VDD VDD sky130_fd_pr__pfet_g5v0d10v5 ad=0 pd=0 as=0 ps=0 w=15 l=0.5
X258 VDD opamp_1/Vg27 Vout2 VDD sky130_fd_pr__pfet_g5v0d10v5 ad=0 pd=0 as=0 ps=0 w=15 l=0.5
X259 VDD opamp_1/Vg27 Vout2 VDD sky130_fd_pr__pfet_g5v0d10v5 ad=0 pd=0 as=0 ps=0 w=15 l=0.5
X260 Vout2 opamp_1/Vg27 VDD VDD sky130_fd_pr__pfet_g5v0d10v5 ad=0 pd=0 as=0 ps=0 w=15 l=0.5
X261 VDD opamp_1/Vg27 Vout2 VDD sky130_fd_pr__pfet_g5v0d10v5 ad=0 pd=0 as=0 ps=0 w=15 l=0.5
X262 VDD opamp_1/Vg27 Vout2 VDD sky130_fd_pr__pfet_g5v0d10v5 ad=0 pd=0 as=0 ps=0 w=15 l=0.5
X263 Vout2 opamp_1/Vg27 VDD VDD sky130_fd_pr__pfet_g5v0d10v5 ad=0 pd=0 as=0 ps=0 w=15 l=0.5
X264 VDD opamp_1/Vg27 Vout2 VDD sky130_fd_pr__pfet_g5v0d10v5 ad=0 pd=0 as=0 ps=0 w=15 l=0.5
X265 Vout2 opamp_1/Vg27 VDD VDD sky130_fd_pr__pfet_g5v0d10v5 ad=0 pd=0 as=0 ps=0 w=15 l=0.5
X266 VDD opamp_1/Vg27 Vout2 VDD sky130_fd_pr__pfet_g5v0d10v5 ad=0 pd=0 as=0 ps=0 w=15 l=0.5
X267 Vout2 opamp_1/Vg27 VDD VDD sky130_fd_pr__pfet_g5v0d10v5 ad=0 pd=0 as=0 ps=0 w=15 l=0.5
X268 VDD opamp_1/Vg27 Vout2 VDD sky130_fd_pr__pfet_g5v0d10v5 ad=0 pd=0 as=0 ps=0 w=15 l=0.5
X269 VDD opamp_1/Vg27 Vout2 VDD sky130_fd_pr__pfet_g5v0d10v5 ad=0 pd=0 as=0 ps=0 w=15 l=0.5
X270 Vout2 opamp_1/Vg27 VDD VDD sky130_fd_pr__pfet_g5v0d10v5 ad=0 pd=0 as=0 ps=0 w=15 l=0.5
X271 VDD opamp_1/Vg27 Vout2 VDD sky130_fd_pr__pfet_g5v0d10v5 ad=0 pd=0 as=0 ps=0 w=15 l=0.5
X272 GND Vref opamp_1/VgR2 GND sky130_fd_pr__nfet_g5v0d10v5 ad=0 pd=0 as=1.45 ps=10.58 w=5 l=8
X273 opamp_1/VgR2 opamp_1/VgR2 VDD VDD sky130_fd_pr__pfet_g5v0d10v5 ad=1.16 pd=8.58 as=0 ps=0 w=4 l=5
X274 opamp_1/Vg1 opamp_1/VgR2 VDD VDD sky130_fd_pr__pfet_g5v0d10v5 ad=1.16 pd=8.58 as=0 ps=0 w=4 l=5
X275 opamp_1/Vd9 opamp_1/Vg1 opamp_1/Vg28 GND sky130_fd_pr__nfet_g5v0d10v5 ad=19.488 pd=137.3 as=25.288 ps=178.46001 w=14.3 l=2
X276 opamp_1/Vd9 opamp_1/Vg1 opamp_1/Vg28 GND sky130_fd_pr__nfet_g5v0d10v5 ad=0 pd=0 as=0 ps=0 w=14.3 l=2
X277 opamp_1/Vg28 opamp_1/Vg1 opamp_1/Vd9 GND sky130_fd_pr__nfet_g5v0d10v5 ad=0 pd=0 as=0 ps=0 w=14.3 l=2
X278 opamp_1/Vd9 opamp_1/Vg1 opamp_1/Vg28 GND sky130_fd_pr__nfet_g5v0d10v5 ad=0 pd=0 as=0 ps=0 w=14.3 l=2
X279 opamp_1/Vg28 opamp_1/Vg1 opamp_1/Vd9 GND sky130_fd_pr__nfet_g5v0d10v5 ad=0 pd=0 as=0 ps=0 w=14.3 l=2
X280 opamp_1/Vd9 opamp_1/Vg1 opamp_1/Vg28 GND sky130_fd_pr__nfet_g5v0d10v5 ad=0 pd=0 as=0 ps=0 w=14.3 l=2
X281 opamp_1/Vg28 opamp_1/Vg1 opamp_1/Vd9 GND sky130_fd_pr__nfet_g5v0d10v5 ad=0 pd=0 as=0 ps=0 w=14.3 l=2
X282 GND opamp_1/Vg1 opamp_1/Vd9 GND sky130_fd_pr__nfet_g5v0d10v5 ad=0 pd=0 as=0 ps=0 w=10 l=5
X283 opamp_1/m25_26_0/m1_160_1028# opamp_1/m25_26_0/m1_160_1028# GND GND sky130_fd_pr__nfet_g5v0d10v5 ad=8.7 pd=63.48 as=0 ps=0 w=5 l=0.5
X284 opamp_1/m25_26_0/m1_160_1028# opamp_1/m25_26_0/m1_160_1028# GND GND sky130_fd_pr__nfet_g5v0d10v5 ad=0 pd=0 as=0 ps=0 w=5 l=0.5
X285 GND opamp_1/m25_26_0/m1_160_1028# opamp_1/m25_26_0/m1_160_1028# GND sky130_fd_pr__nfet_g5v0d10v5 ad=0 pd=0 as=0 ps=0 w=5 l=0.5
X286 GND opamp_1/m25_26_0/m1_160_1028# opamp_1/m25_26_0/m1_160_1028# GND sky130_fd_pr__nfet_g5v0d10v5 ad=0 pd=0 as=0 ps=0 w=5 l=0.5
X287 GND opamp_1/m25_26_0/m1_160_1028# opamp_1/m25_26_0/m1_160_1028# GND sky130_fd_pr__nfet_g5v0d10v5 ad=0 pd=0 as=0 ps=0 w=5 l=0.5
X288 opamp_1/Vd24 opamp_1/Vd24 opamp_1/m25_26_0/m1_160_1028# GND sky130_fd_pr__nfet_g5v0d10v5 ad=4.35 pd=31.74 as=0 ps=0 w=5 l=0.5
X289 opamp_1/Vd24 opamp_1/Vd24 opamp_1/m25_26_0/m1_160_1028# GND sky130_fd_pr__nfet_g5v0d10v5 ad=0 pd=0 as=0 ps=0 w=5 l=0.5
X290 opamp_1/m25_26_0/m1_160_1028# opamp_1/Vd24 opamp_1/Vd24 GND sky130_fd_pr__nfet_g5v0d10v5 ad=0 pd=0 as=0 ps=0 w=5 l=0.5
X291 opamp_1/m25_26_0/m1_160_1028# opamp_1/Vd24 opamp_1/Vd24 GND sky130_fd_pr__nfet_g5v0d10v5 ad=0 pd=0 as=0 ps=0 w=5 l=0.5
X292 opamp_1/m25_26_0/m1_160_1028# opamp_1/Vd24 opamp_1/Vd24 GND sky130_fd_pr__nfet_g5v0d10v5 ad=0 pd=0 as=0 ps=0 w=5 l=0.5
X293 opamp_1/Vg28 opamp_1/Vd24 opamp_1/Vg27 GND sky130_fd_pr__nfet_g5v0d10v5 ad=0 pd=0 as=8.7 ps=61.74 w=10 l=0.5
X294 opamp_1/Vg28 opamp_1/Vd24 opamp_1/Vg27 GND sky130_fd_pr__nfet_g5v0d10v5 ad=0 pd=0 as=0 ps=0 w=10 l=0.5
X295 opamp_1/Vg28 opamp_1/Vd24 opamp_1/Vg27 GND sky130_fd_pr__nfet_g5v0d10v5 ad=0 pd=0 as=0 ps=0 w=10 l=0.5
X296 opamp_1/Vg27 opamp_1/Vd24 opamp_1/Vg28 GND sky130_fd_pr__nfet_g5v0d10v5 ad=0 pd=0 as=0 ps=0 w=10 l=0.5
X297 opamp_1/Vg27 opamp_1/Vd24 opamp_1/Vg28 GND sky130_fd_pr__nfet_g5v0d10v5 ad=0 pd=0 as=0 ps=0 w=10 l=0.5
X298 opamp_1/Vg11 opamp_1/Vg11 opamp_1/Vd30 VDD sky130_fd_pr__pfet_g5v0d10v5 ad=8.7 pd=61.74 as=17.4 ps=123.48 w=10 l=1
X299 opamp_1/Vd30 opamp_1/Vg11 opamp_1/Vg11 VDD sky130_fd_pr__pfet_g5v0d10v5 ad=0 pd=0 as=0 ps=0 w=10 l=1
X300 opamp_1/Vd30 opamp_1/Vg11 opamp_1/Vg11 VDD sky130_fd_pr__pfet_g5v0d10v5 ad=0 pd=0 as=0 ps=0 w=10 l=1
X301 opamp_1/Vg11 opamp_1/Vg11 opamp_1/Vd30 VDD sky130_fd_pr__pfet_g5v0d10v5 ad=0 pd=0 as=0 ps=0 w=10 l=1
X302 opamp_1/Vg11 opamp_1/Vg11 opamp_1/Vd30 VDD sky130_fd_pr__pfet_g5v0d10v5 ad=0 pd=0 as=0 ps=0 w=10 l=1
X303 opamp_1/Vd30 opamp_1/Vg11 VDD VDD sky130_fd_pr__pfet_g5v0d10v5 ad=0 pd=0 as=0 ps=0 w=10 l=2.5
X304 VDD opamp_1/Vg11 opamp_1/Vd30 VDD sky130_fd_pr__pfet_g5v0d10v5 ad=0 pd=0 as=0 ps=0 w=10 l=2.5
X305 VDD opamp_1/Vg11 opamp_1/Vd30 VDD sky130_fd_pr__pfet_g5v0d10v5 ad=0 pd=0 as=0 ps=0 w=10 l=2.5
X306 opamp_1/Vd30 opamp_1/Vg11 VDD VDD sky130_fd_pr__pfet_g5v0d10v5 ad=0 pd=0 as=0 ps=0 w=10 l=2.5
X307 opamp_1/Vd30 opamp_1/Vg11 VDD VDD sky130_fd_pr__pfet_g5v0d10v5 ad=0 pd=0 as=0 ps=0 w=10 l=2.5
X308 opamp_1/Vg27 Vout2 sky130_fd_pr__cap_mim_m3_1 l=20 w=30
X309 opamp_1/Vg27 Vout2 sky130_fd_pr__cap_mim_m3_1 l=20 w=30
X310 opamp_1/Vg27 Vout2 sky130_fd_pr__cap_mim_m3_1 l=20 w=30
X311 opamp_1/Vg27 Vout2 sky130_fd_pr__cap_mim_m3_1 l=20 w=30
X312 opamp_1/Vg28 Vout2 sky130_fd_pr__cap_mim_m3_1 l=20 w=30
X313 opamp_1/Vg28 Vout2 sky130_fd_pr__cap_mim_m3_1 l=20 w=30
X314 opamp_1/Vg28 Vout2 sky130_fd_pr__cap_mim_m3_1 l=20 w=30
X315 opamp_1/Vg28 Vout2 sky130_fd_pr__cap_mim_m3_1 l=20 w=30
X316 opamp_1/Vg1 opamp_1/Vg1 opamp_1/m01_02/sky130_fd_pr__nfet_g5v0d10v5_Y3KDPX_0/D GND sky130_fd_pr__nfet_g5v0d10v5 ad=1.9314 pd=14.48 as=3.3814 ps=25.06 w=3.33 l=2
X317 opamp_1/m01_02/sky130_fd_pr__nfet_g5v0d10v5_Y3KDPX_0/D opamp_1/Vg1 opamp_1/Vg1 GND sky130_fd_pr__nfet_g5v0d10v5 ad=0 pd=0 as=0 ps=0 w=3.33 l=2
X318 opamp_1/m01_02/sky130_fd_pr__nfet_g5v0d10v5_Y3KDPX_0/D opamp_1/Vg1 opamp_1/Vg1 GND sky130_fd_pr__nfet_g5v0d10v5 ad=0 pd=0 as=0 ps=0 w=3.33 l=2
X319 GND opamp_1/Vg1 opamp_1/m01_02/sky130_fd_pr__nfet_g5v0d10v5_Y3KDPX_0/D GND sky130_fd_pr__nfet_g5v0d10v5 ad=0 pd=0 as=0 ps=0 w=5 l=5
X320 Vout2 opamp_1/Vg28 GND GND sky130_fd_pr__nfet_g5v0d10v5 ad=23.2 pd=164.64 as=0 ps=0 w=10 l=0.5
X321 Vout2 opamp_1/Vg28 GND GND sky130_fd_pr__nfet_g5v0d10v5 ad=0 pd=0 as=0 ps=0 w=10 l=0.5
X322 GND opamp_1/Vg28 Vout2 GND sky130_fd_pr__nfet_g5v0d10v5 ad=0 pd=0 as=0 ps=0 w=10 l=0.5
X323 Vout2 opamp_1/Vg28 GND GND sky130_fd_pr__nfet_g5v0d10v5 ad=0 pd=0 as=0 ps=0 w=10 l=0.5
X324 Vout2 opamp_1/Vg28 GND GND sky130_fd_pr__nfet_g5v0d10v5 ad=0 pd=0 as=0 ps=0 w=10 l=0.5
X325 Vout2 opamp_1/Vg28 GND GND sky130_fd_pr__nfet_g5v0d10v5 ad=0 pd=0 as=0 ps=0 w=10 l=0.5
X326 GND opamp_1/Vg28 Vout2 GND sky130_fd_pr__nfet_g5v0d10v5 ad=0 pd=0 as=0 ps=0 w=10 l=0.5
X327 Vout2 opamp_1/Vg28 GND GND sky130_fd_pr__nfet_g5v0d10v5 ad=0 pd=0 as=0 ps=0 w=10 l=0.5
X328 GND opamp_1/Vg28 Vout2 GND sky130_fd_pr__nfet_g5v0d10v5 ad=0 pd=0 as=0 ps=0 w=10 l=0.5
X329 GND opamp_1/Vg28 Vout2 GND sky130_fd_pr__nfet_g5v0d10v5 ad=0 pd=0 as=0 ps=0 w=10 l=0.5
X330 GND opamp_1/Vg28 Vout2 GND sky130_fd_pr__nfet_g5v0d10v5 ad=0 pd=0 as=0 ps=0 w=10 l=0.5
X331 GND opamp_1/Vg28 Vout2 GND sky130_fd_pr__nfet_g5v0d10v5 ad=0 pd=0 as=0 ps=0 w=10 l=0.5
X332 GND opamp_1/Vg28 Vout2 GND sky130_fd_pr__nfet_g5v0d10v5 ad=0 pd=0 as=0 ps=0 w=10 l=0.5
X333 GND opamp_1/Vg28 Vout2 GND sky130_fd_pr__nfet_g5v0d10v5 ad=0 pd=0 as=0 ps=0 w=10 l=0.5
X334 Vout2 opamp_1/Vg28 GND GND sky130_fd_pr__nfet_g5v0d10v5 ad=0 pd=0 as=0 ps=0 w=10 l=0.5
X335 opamp_1/Vs29 Vn opamp_1/Vd29 GND sky130_fd_pr__nfet_g5v0d10v5 ad=0 pd=0 as=16.1095 ps=114 w=11.11 l=1.5
X336 opamp_1/Vs29 Vn opamp_1/Vd29 GND sky130_fd_pr__nfet_g5v0d10v5 ad=0 pd=0 as=0 ps=0 w=11.11 l=1.5
X337 opamp_1/Vs29 Vn opamp_1/Vd29 GND sky130_fd_pr__nfet_g5v0d10v5 ad=0 pd=0 as=0 ps=0 w=11.11 l=1.5
X338 opamp_1/Vd29 Vn opamp_1/Vs29 GND sky130_fd_pr__nfet_g5v0d10v5 ad=0 pd=0 as=0 ps=0 w=11.11 l=1.5
X339 opamp_1/Vd29 Vn opamp_1/Vs29 GND sky130_fd_pr__nfet_g5v0d10v5 ad=0 pd=0 as=0 ps=0 w=11.11 l=1.5
X340 opamp_1/Vd29 Vn opamp_1/Vs29 GND sky130_fd_pr__nfet_g5v0d10v5 ad=0 pd=0 as=0 ps=0 w=11.11 l=1.5
X341 opamp_1/Vd29 Vn opamp_1/Vs29 GND sky130_fd_pr__nfet_g5v0d10v5 ad=0 pd=0 as=0 ps=0 w=11.11 l=1.5
X342 opamp_1/Vs29 Vn opamp_1/Vd29 GND sky130_fd_pr__nfet_g5v0d10v5 ad=0 pd=0 as=0 ps=0 w=11.11 l=1.5
X343 opamp_1/Vs29 Vn opamp_1/Vd29 GND sky130_fd_pr__nfet_g5v0d10v5 ad=0 pd=0 as=0 ps=0 w=11.11 l=1.5
X344 opamp_1/Vs29 Rgn opamp_1/Vd30 GND sky130_fd_pr__nfet_g5v0d10v5 ad=0 pd=0 as=16.1095 ps=114 w=11.11 l=1.5
X345 opamp_1/Vs29 Rgn opamp_1/Vd30 GND sky130_fd_pr__nfet_g5v0d10v5 ad=0 pd=0 as=0 ps=0 w=11.11 l=1.5
X346 opamp_1/Vs29 Rgn opamp_1/Vd30 GND sky130_fd_pr__nfet_g5v0d10v5 ad=0 pd=0 as=0 ps=0 w=11.11 l=1.5
X347 opamp_1/Vd30 Rgn opamp_1/Vs29 GND sky130_fd_pr__nfet_g5v0d10v5 ad=0 pd=0 as=0 ps=0 w=11.11 l=1.5
X348 opamp_1/Vd30 Rgn opamp_1/Vs29 GND sky130_fd_pr__nfet_g5v0d10v5 ad=0 pd=0 as=0 ps=0 w=11.11 l=1.5
X349 opamp_1/Vd30 Rgn opamp_1/Vs29 GND sky130_fd_pr__nfet_g5v0d10v5 ad=0 pd=0 as=0 ps=0 w=11.11 l=1.5
X350 opamp_1/Vd30 Rgn opamp_1/Vs29 GND sky130_fd_pr__nfet_g5v0d10v5 ad=0 pd=0 as=0 ps=0 w=11.11 l=1.5
X351 opamp_1/Vs29 Rgn opamp_1/Vd30 GND sky130_fd_pr__nfet_g5v0d10v5 ad=0 pd=0 as=0 ps=0 w=11.11 l=1.5
X352 opamp_1/Vs29 Rgn opamp_1/Vd30 GND sky130_fd_pr__nfet_g5v0d10v5 ad=0 pd=0 as=0 ps=0 w=11.11 l=1.5
X353 VDD opamp_1/m21_22_0/G opamp_1/m21_22_0/G VDD sky130_fd_pr__pfet_g5v0d10v5 ad=0 pd=0 as=26.1 ps=183.48 w=15 l=0.5
X354 VDD opamp_1/m21_22_0/G opamp_1/m21_22_0/G VDD sky130_fd_pr__pfet_g5v0d10v5 ad=0 pd=0 as=0 ps=0 w=15 l=0.5
X355 opamp_1/m21_22_0/G opamp_1/m21_22_0/G VDD VDD sky130_fd_pr__pfet_g5v0d10v5 ad=0 pd=0 as=0 ps=0 w=15 l=0.5
X356 VDD opamp_1/m21_22_0/G opamp_1/m21_22_0/G VDD sky130_fd_pr__pfet_g5v0d10v5 ad=0 pd=0 as=0 ps=0 w=15 l=0.5
X357 opamp_1/m21_22_0/G opamp_1/m21_22_0/G VDD VDD sky130_fd_pr__pfet_g5v0d10v5 ad=0 pd=0 as=0 ps=0 w=15 l=0.5
X358 opamp_1/m21_22_0/G opamp_1/Vg22 opamp_1/Vg22 VDD sky130_fd_pr__pfet_g5v0d10v5 ad=0 pd=0 as=13.05 ps=91.74 w=15 l=0.5
X359 opamp_1/m21_22_0/G opamp_1/Vg22 opamp_1/Vg22 VDD sky130_fd_pr__pfet_g5v0d10v5 ad=0 pd=0 as=0 ps=0 w=15 l=0.5
X360 opamp_1/Vg22 opamp_1/Vg22 opamp_1/m21_22_0/G VDD sky130_fd_pr__pfet_g5v0d10v5 ad=0 pd=0 as=0 ps=0 w=15 l=0.5
X361 opamp_1/m21_22_0/G opamp_1/Vg22 opamp_1/Vg22 VDD sky130_fd_pr__pfet_g5v0d10v5 ad=0 pd=0 as=0 ps=0 w=15 l=0.5
X362 opamp_1/Vg22 opamp_1/Vg22 opamp_1/m21_22_0/G VDD sky130_fd_pr__pfet_g5v0d10v5 ad=0 pd=0 as=0 ps=0 w=15 l=0.5
X363 opamp_1/Vg27 opamp_1/Vg22 opamp_1/Vg28 VDD sky130_fd_pr__pfet_g5v0d10v5 ad=0 pd=0 as=23.2 ps=164.64 w=10 l=0.5
X364 opamp_1/Vg27 opamp_1/Vg22 opamp_1/Vg28 VDD sky130_fd_pr__pfet_g5v0d10v5 ad=0 pd=0 as=0 ps=0 w=10 l=0.5
X365 opamp_1/Vg27 opamp_1/Vg22 opamp_1/Vg28 VDD sky130_fd_pr__pfet_g5v0d10v5 ad=0 pd=0 as=0 ps=0 w=10 l=0.5
X366 opamp_1/Vg28 opamp_1/Vg22 opamp_1/Vg27 VDD sky130_fd_pr__pfet_g5v0d10v5 ad=0 pd=0 as=0 ps=0 w=10 l=0.5
X367 opamp_1/Vg27 opamp_1/Vg22 opamp_1/Vg28 VDD sky130_fd_pr__pfet_g5v0d10v5 ad=0 pd=0 as=0 ps=0 w=10 l=0.5
X368 opamp_1/Vg27 opamp_1/Vg22 opamp_1/Vg28 VDD sky130_fd_pr__pfet_g5v0d10v5 ad=0 pd=0 as=0 ps=0 w=10 l=0.5
X369 opamp_1/Vg27 opamp_1/Vg22 opamp_1/Vg28 VDD sky130_fd_pr__pfet_g5v0d10v5 ad=0 pd=0 as=0 ps=0 w=10 l=0.5
X370 opamp_1/Vg28 opamp_1/Vg22 opamp_1/Vg27 VDD sky130_fd_pr__pfet_g5v0d10v5 ad=0 pd=0 as=0 ps=0 w=10 l=0.5
X371 opamp_1/Vg27 opamp_1/Vg22 opamp_1/Vg28 VDD sky130_fd_pr__pfet_g5v0d10v5 ad=0 pd=0 as=0 ps=0 w=10 l=0.5
X372 opamp_1/Vg28 opamp_1/Vg22 opamp_1/Vg27 VDD sky130_fd_pr__pfet_g5v0d10v5 ad=0 pd=0 as=0 ps=0 w=10 l=0.5
X373 opamp_1/Vg28 opamp_1/Vg22 opamp_1/Vg27 VDD sky130_fd_pr__pfet_g5v0d10v5 ad=0 pd=0 as=0 ps=0 w=10 l=0.5
X374 opamp_1/Vg28 opamp_1/Vg22 opamp_1/Vg27 VDD sky130_fd_pr__pfet_g5v0d10v5 ad=0 pd=0 as=0 ps=0 w=10 l=0.5
X375 opamp_1/Vg28 opamp_1/Vg22 opamp_1/Vg27 VDD sky130_fd_pr__pfet_g5v0d10v5 ad=0 pd=0 as=0 ps=0 w=10 l=0.5
X376 opamp_1/Vg28 opamp_1/Vg22 opamp_1/Vg27 VDD sky130_fd_pr__pfet_g5v0d10v5 ad=0 pd=0 as=0 ps=0 w=10 l=0.5
X377 opamp_1/Vg28 opamp_1/Vg22 opamp_1/Vg27 VDD sky130_fd_pr__pfet_g5v0d10v5 ad=0 pd=0 as=0 ps=0 w=10 l=0.5
X378 opamp_1/m5_m6_0/m1_4014_7500# opamp_1/Vg5 VDD VDD sky130_fd_pr__pfet_g5v0d10v5 ad=6.728 pd=48.72 as=0 ps=0 w=5 l=5
X379 VDD opamp_1/Vg5 opamp_1/m5_m6_0/m1_4014_7500# VDD sky130_fd_pr__pfet_g5v0d10v5 ad=0 pd=0 as=0 ps=0 w=5 l=5
X380 opamp_1/m5_m6_0/m1_4014_7500# opamp_1/Vg5 VDD VDD sky130_fd_pr__pfet_g5v0d10v5 ad=0 pd=0 as=0 ps=0 w=5 l=5
X381 opamp_1/m5_m6_0/m1_4014_7500# opamp_1/Vg5 opamp_1/Vg5 VDD sky130_fd_pr__pfet_g5v0d10v5 ad=0 pd=0 as=3.828 ps=27.56 w=6.6 l=2
X382 opamp_1/Vg5 opamp_1/Vg5 opamp_1/m5_m6_0/m1_4014_7500# VDD sky130_fd_pr__pfet_g5v0d10v5 ad=0 pd=0 as=0 ps=0 w=6.6 l=2
X383 opamp_1/Vg5 opamp_1/Vg5 opamp_1/m5_m6_0/m1_4014_7500# VDD sky130_fd_pr__pfet_g5v0d10v5 ad=0 pd=0 as=0 ps=0 w=6.6 l=2
X384 opamp_2/Vg27 opamp_2/Vg11 opamp_2/Vd29 VDD sky130_fd_pr__pfet_g5v0d10v5 ad=31.9 pd=226.38 as=17.4 ps=123.48 w=10 l=1
X385 opamp_2/Vd29 opamp_2/Vg11 opamp_2/Vg27 VDD sky130_fd_pr__pfet_g5v0d10v5 ad=0 pd=0 as=0 ps=0 w=10 l=1
X386 opamp_2/Vd29 opamp_2/Vg11 opamp_2/Vg27 VDD sky130_fd_pr__pfet_g5v0d10v5 ad=0 pd=0 as=0 ps=0 w=10 l=1
X387 opamp_2/Vg27 opamp_2/Vg11 opamp_2/Vd29 VDD sky130_fd_pr__pfet_g5v0d10v5 ad=0 pd=0 as=0 ps=0 w=10 l=1
X388 opamp_2/Vg27 opamp_2/Vg11 opamp_2/Vd29 VDD sky130_fd_pr__pfet_g5v0d10v5 ad=0 pd=0 as=0 ps=0 w=10 l=1
X389 opamp_2/Vd29 opamp_2/Vg11 VDD VDD sky130_fd_pr__pfet_g5v0d10v5 ad=0 pd=0 as=0 ps=0 w=10 l=2.5
X390 VDD opamp_2/Vg11 opamp_2/Vd29 VDD sky130_fd_pr__pfet_g5v0d10v5 ad=0 pd=0 as=0 ps=0 w=10 l=2.5
X391 VDD opamp_2/Vg11 opamp_2/Vd29 VDD sky130_fd_pr__pfet_g5v0d10v5 ad=0 pd=0 as=0 ps=0 w=10 l=2.5
X392 opamp_2/Vd29 opamp_2/Vg11 VDD VDD sky130_fd_pr__pfet_g5v0d10v5 ad=0 pd=0 as=0 ps=0 w=10 l=2.5
X393 opamp_2/Vd29 opamp_2/Vg11 VDD VDD sky130_fd_pr__pfet_g5v0d10v5 ad=0 pd=0 as=0 ps=0 w=10 l=2.5
X394 GND opamp_2/Vg1 opamp_2/Vg22 GND sky130_fd_pr__nfet_g5v0d10v5 ad=0 pd=0 as=0.435 ps=3.58 w=1.5 l=5
X395 opamp_2/Vd24 opamp_2/Vg5 VDD VDD sky130_fd_pr__pfet_g5v0d10v5 ad=1.16 pd=8.58 as=0 ps=0 w=4 l=5
X396 opamp_2/m07_08_0/m1_29362_10250# opamp_2/Vg5 opamp_2/Vd8 VDD sky130_fd_pr__pfet_g5v0d10v5 ad=13.456 pd=95.12 as=72.094 ps=504.16 w=13.2 l=2
X397 opamp_2/Vd8 opamp_2/Vg5 opamp_2/m07_08_0/m1_29362_10250# VDD sky130_fd_pr__pfet_g5v0d10v5 ad=0 pd=0 as=0 ps=0 w=13.2 l=2
X398 opamp_2/Vd8 opamp_2/Vg5 opamp_2/m07_08_0/m1_29362_10250# VDD sky130_fd_pr__pfet_g5v0d10v5 ad=0 pd=0 as=0 ps=0 w=13.2 l=2
X399 VDD opamp_2/Vg5 opamp_2/m07_08_0/m1_29362_10250# VDD sky130_fd_pr__pfet_g5v0d10v5 ad=0 pd=0 as=0 ps=0 w=10 l=5
X400 opamp_2/m07_08_0/m1_29362_10250# opamp_2/Vg5 VDD VDD sky130_fd_pr__pfet_g5v0d10v5 ad=0 pd=0 as=0 ps=0 w=10 l=5
X401 opamp_2/m07_08_0/m1_29362_10250# opamp_2/Vg5 VDD VDD sky130_fd_pr__pfet_g5v0d10v5 ad=0 pd=0 as=0 ps=0 w=10 l=5
X402 opamp_2/Vd10 opamp_2/Vg1 opamp_2/Vg11 GND sky130_fd_pr__nfet_g5v0d10v5 ad=19.488 pd=137.3 as=16.588 ps=116.72 w=14.3 l=2
X403 opamp_2/Vd10 opamp_2/Vg1 opamp_2/Vg11 GND sky130_fd_pr__nfet_g5v0d10v5 ad=0 pd=0 as=0 ps=0 w=14.3 l=2
X404 opamp_2/Vg11 opamp_2/Vg1 opamp_2/Vd10 GND sky130_fd_pr__nfet_g5v0d10v5 ad=0 pd=0 as=0 ps=0 w=14.3 l=2
X405 opamp_2/Vd10 opamp_2/Vg1 opamp_2/Vg11 GND sky130_fd_pr__nfet_g5v0d10v5 ad=0 pd=0 as=0 ps=0 w=14.3 l=2
X406 opamp_2/Vg11 opamp_2/Vg1 opamp_2/Vd10 GND sky130_fd_pr__nfet_g5v0d10v5 ad=0 pd=0 as=0 ps=0 w=14.3 l=2
X407 opamp_2/Vd10 opamp_2/Vg1 opamp_2/Vg11 GND sky130_fd_pr__nfet_g5v0d10v5 ad=0 pd=0 as=0 ps=0 w=14.3 l=2
X408 opamp_2/Vg11 opamp_2/Vg1 opamp_2/Vd10 GND sky130_fd_pr__nfet_g5v0d10v5 ad=0 pd=0 as=0 ps=0 w=14.3 l=2
X409 GND opamp_2/Vg1 opamp_2/Vd10 GND sky130_fd_pr__nfet_g5v0d10v5 ad=0 pd=0 as=0 ps=0 w=10 l=5
X410 opamp_2/Vs29 opamp_2/Vg1 opamp_2/m31_32_0/m1_21854_12984# GND sky130_fd_pr__nfet_g5v0d10v5 ad=36.0818 pd=255.8 as=6.7628 ps=48.38 w=6.66 l=2
X411 opamp_2/m31_32_0/m1_21854_12984# opamp_2/Vg1 opamp_2/Vs29 GND sky130_fd_pr__nfet_g5v0d10v5 ad=0 pd=0 as=0 ps=0 w=6.66 l=2
X412 opamp_2/m31_32_0/m1_21854_12984# opamp_2/Vg1 opamp_2/Vs29 GND sky130_fd_pr__nfet_g5v0d10v5 ad=0 pd=0 as=0 ps=0 w=6.66 l=2
X413 GND opamp_2/Vg1 opamp_2/m31_32_0/m1_21854_12984# GND sky130_fd_pr__nfet_g5v0d10v5 ad=0 pd=0 as=0 ps=0 w=10 l=5
X414 opamp_2/Vd9 Vp opamp_2/Vd8 opamp_2/Vd8 sky130_fd_pr__pfet_g5v0d10v5 ad=32.219 pd=225.10001 as=0 ps=0 w=22.22 l=1.5
X415 opamp_2/Vd9 Vp opamp_2/Vd8 opamp_2/Vd8 sky130_fd_pr__pfet_g5v0d10v5 ad=0 pd=0 as=0 ps=0 w=22.22 l=1.5
X416 opamp_2/Vd9 Vp opamp_2/Vd8 opamp_2/Vd8 sky130_fd_pr__pfet_g5v0d10v5 ad=0 pd=0 as=0 ps=0 w=22.22 l=1.5
X417 opamp_2/Vd9 Vp opamp_2/Vd8 opamp_2/Vd8 sky130_fd_pr__pfet_g5v0d10v5 ad=0 pd=0 as=0 ps=0 w=22.22 l=1.5
X418 opamp_2/Vd9 Vp opamp_2/Vd8 opamp_2/Vd8 sky130_fd_pr__pfet_g5v0d10v5 ad=0 pd=0 as=0 ps=0 w=22.22 l=1.5
X419 opamp_2/Vd8 Vp opamp_2/Vd9 opamp_2/Vd8 sky130_fd_pr__pfet_g5v0d10v5 ad=0 pd=0 as=0 ps=0 w=22.22 l=1.5
X420 opamp_2/Vd8 Vp opamp_2/Vd9 opamp_2/Vd8 sky130_fd_pr__pfet_g5v0d10v5 ad=0 pd=0 as=0 ps=0 w=22.22 l=1.5
X421 opamp_2/Vd8 Vp opamp_2/Vd9 opamp_2/Vd8 sky130_fd_pr__pfet_g5v0d10v5 ad=0 pd=0 as=0 ps=0 w=22.22 l=1.5
X422 opamp_2/Vd8 Vp opamp_2/Vd9 opamp_2/Vd8 sky130_fd_pr__pfet_g5v0d10v5 ad=0 pd=0 as=0 ps=0 w=22.22 l=1.5
X423 opamp_2/Vd10 Rgp opamp_2/Vd8 opamp_2/Vd8 sky130_fd_pr__pfet_g5v0d10v5 ad=32.219 pd=225.10001 as=0 ps=0 w=22.22 l=1.5
X424 opamp_2/Vd10 Rgp opamp_2/Vd8 opamp_2/Vd8 sky130_fd_pr__pfet_g5v0d10v5 ad=0 pd=0 as=0 ps=0 w=22.22 l=1.5
X425 opamp_2/Vd10 Rgp opamp_2/Vd8 opamp_2/Vd8 sky130_fd_pr__pfet_g5v0d10v5 ad=0 pd=0 as=0 ps=0 w=22.22 l=1.5
X426 opamp_2/Vd10 Rgp opamp_2/Vd8 opamp_2/Vd8 sky130_fd_pr__pfet_g5v0d10v5 ad=0 pd=0 as=0 ps=0 w=22.22 l=1.5
X427 opamp_2/Vd10 Rgp opamp_2/Vd8 opamp_2/Vd8 sky130_fd_pr__pfet_g5v0d10v5 ad=0 pd=0 as=0 ps=0 w=22.22 l=1.5
X428 opamp_2/Vd8 Rgp opamp_2/Vd10 opamp_2/Vd8 sky130_fd_pr__pfet_g5v0d10v5 ad=0 pd=0 as=0 ps=0 w=22.22 l=1.5
X429 opamp_2/Vd8 Rgp opamp_2/Vd10 opamp_2/Vd8 sky130_fd_pr__pfet_g5v0d10v5 ad=0 pd=0 as=0 ps=0 w=22.22 l=1.5
X430 opamp_2/Vd8 Rgp opamp_2/Vd10 opamp_2/Vd8 sky130_fd_pr__pfet_g5v0d10v5 ad=0 pd=0 as=0 ps=0 w=22.22 l=1.5
X431 opamp_2/Vd8 Rgp opamp_2/Vd10 opamp_2/Vd8 sky130_fd_pr__pfet_g5v0d10v5 ad=0 pd=0 as=0 ps=0 w=22.22 l=1.5
X432 opamp_2/Vg5 opamp_2/Vg1 opamp_2/M03_04/sky130_fd_pr__nfet_g5v0d10v5_Y3KDPX_0/D GND sky130_fd_pr__nfet_g5v0d10v5 ad=1.9314 pd=14.48 as=3.3814 ps=25.06 w=3.33 l=2
X433 opamp_2/M03_04/sky130_fd_pr__nfet_g5v0d10v5_Y3KDPX_0/D opamp_2/Vg1 opamp_2/Vg5 GND sky130_fd_pr__nfet_g5v0d10v5 ad=0 pd=0 as=0 ps=0 w=3.33 l=2
X434 opamp_2/M03_04/sky130_fd_pr__nfet_g5v0d10v5_Y3KDPX_0/D opamp_2/Vg1 opamp_2/Vg5 GND sky130_fd_pr__nfet_g5v0d10v5 ad=0 pd=0 as=0 ps=0 w=3.33 l=2
X435 GND opamp_2/Vg1 opamp_2/M03_04/sky130_fd_pr__nfet_g5v0d10v5_Y3KDPX_0/D GND sky130_fd_pr__nfet_g5v0d10v5 ad=0 pd=0 as=0 ps=0 w=5 l=5
X436 Vout3 opamp_2/Vg27 VDD VDD sky130_fd_pr__pfet_g5v0d10v5 ad=56.55 pd=397.54001 as=0 ps=0 w=15 l=0.5
X437 Vout3 opamp_2/Vg27 VDD VDD sky130_fd_pr__pfet_g5v0d10v5 ad=0 pd=0 as=0 ps=0 w=15 l=0.5
X438 Vout3 opamp_2/Vg27 VDD VDD sky130_fd_pr__pfet_g5v0d10v5 ad=0 pd=0 as=0 ps=0 w=15 l=0.5
X439 VDD opamp_2/Vg27 Vout3 VDD sky130_fd_pr__pfet_g5v0d10v5 ad=0 pd=0 as=0 ps=0 w=15 l=0.5
X440 Vout3 opamp_2/Vg27 VDD VDD sky130_fd_pr__pfet_g5v0d10v5 ad=0 pd=0 as=0 ps=0 w=15 l=0.5
X441 VDD opamp_2/Vg27 Vout3 VDD sky130_fd_pr__pfet_g5v0d10v5 ad=0 pd=0 as=0 ps=0 w=15 l=0.5
X442 Vout3 opamp_2/Vg27 VDD VDD sky130_fd_pr__pfet_g5v0d10v5 ad=0 pd=0 as=0 ps=0 w=15 l=0.5
X443 Vout3 opamp_2/Vg27 VDD VDD sky130_fd_pr__pfet_g5v0d10v5 ad=0 pd=0 as=0 ps=0 w=15 l=0.5
X444 Vout3 opamp_2/Vg27 VDD VDD sky130_fd_pr__pfet_g5v0d10v5 ad=0 pd=0 as=0 ps=0 w=15 l=0.5
X445 VDD opamp_2/Vg27 Vout3 VDD sky130_fd_pr__pfet_g5v0d10v5 ad=0 pd=0 as=0 ps=0 w=15 l=0.5
X446 Vout3 opamp_2/Vg27 VDD VDD sky130_fd_pr__pfet_g5v0d10v5 ad=0 pd=0 as=0 ps=0 w=15 l=0.5
X447 VDD opamp_2/Vg27 Vout3 VDD sky130_fd_pr__pfet_g5v0d10v5 ad=0 pd=0 as=0 ps=0 w=15 l=0.5
X448 VDD opamp_2/Vg27 Vout3 VDD sky130_fd_pr__pfet_g5v0d10v5 ad=0 pd=0 as=0 ps=0 w=15 l=0.5
X449 Vout3 opamp_2/Vg27 VDD VDD sky130_fd_pr__pfet_g5v0d10v5 ad=0 pd=0 as=0 ps=0 w=15 l=0.5
X450 VDD opamp_2/Vg27 Vout3 VDD sky130_fd_pr__pfet_g5v0d10v5 ad=0 pd=0 as=0 ps=0 w=15 l=0.5
X451 VDD opamp_2/Vg27 Vout3 VDD sky130_fd_pr__pfet_g5v0d10v5 ad=0 pd=0 as=0 ps=0 w=15 l=0.5
X452 Vout3 opamp_2/Vg27 VDD VDD sky130_fd_pr__pfet_g5v0d10v5 ad=0 pd=0 as=0 ps=0 w=15 l=0.5
X453 VDD opamp_2/Vg27 Vout3 VDD sky130_fd_pr__pfet_g5v0d10v5 ad=0 pd=0 as=0 ps=0 w=15 l=0.5
X454 Vout3 opamp_2/Vg27 VDD VDD sky130_fd_pr__pfet_g5v0d10v5 ad=0 pd=0 as=0 ps=0 w=15 l=0.5
X455 VDD opamp_2/Vg27 Vout3 VDD sky130_fd_pr__pfet_g5v0d10v5 ad=0 pd=0 as=0 ps=0 w=15 l=0.5
X456 Vout3 opamp_2/Vg27 VDD VDD sky130_fd_pr__pfet_g5v0d10v5 ad=0 pd=0 as=0 ps=0 w=15 l=0.5
X457 VDD opamp_2/Vg27 Vout3 VDD sky130_fd_pr__pfet_g5v0d10v5 ad=0 pd=0 as=0 ps=0 w=15 l=0.5
X458 VDD opamp_2/Vg27 Vout3 VDD sky130_fd_pr__pfet_g5v0d10v5 ad=0 pd=0 as=0 ps=0 w=15 l=0.5
X459 Vout3 opamp_2/Vg27 VDD VDD sky130_fd_pr__pfet_g5v0d10v5 ad=0 pd=0 as=0 ps=0 w=15 l=0.5
X460 VDD opamp_2/Vg27 Vout3 VDD sky130_fd_pr__pfet_g5v0d10v5 ad=0 pd=0 as=0 ps=0 w=15 l=0.5
X461 GND Vref opamp_2/VgR2 GND sky130_fd_pr__nfet_g5v0d10v5 ad=0 pd=0 as=1.45 ps=10.58 w=5 l=8
X462 opamp_2/VgR2 opamp_2/VgR2 VDD VDD sky130_fd_pr__pfet_g5v0d10v5 ad=1.16 pd=8.58 as=0 ps=0 w=4 l=5
X463 opamp_2/Vg1 opamp_2/VgR2 VDD VDD sky130_fd_pr__pfet_g5v0d10v5 ad=1.16 pd=8.58 as=0 ps=0 w=4 l=5
X464 opamp_2/Vd9 opamp_2/Vg1 opamp_2/Vg28 GND sky130_fd_pr__nfet_g5v0d10v5 ad=19.488 pd=137.3 as=25.288 ps=178.46001 w=14.3 l=2
X465 opamp_2/Vd9 opamp_2/Vg1 opamp_2/Vg28 GND sky130_fd_pr__nfet_g5v0d10v5 ad=0 pd=0 as=0 ps=0 w=14.3 l=2
X466 opamp_2/Vg28 opamp_2/Vg1 opamp_2/Vd9 GND sky130_fd_pr__nfet_g5v0d10v5 ad=0 pd=0 as=0 ps=0 w=14.3 l=2
X467 opamp_2/Vd9 opamp_2/Vg1 opamp_2/Vg28 GND sky130_fd_pr__nfet_g5v0d10v5 ad=0 pd=0 as=0 ps=0 w=14.3 l=2
X468 opamp_2/Vg28 opamp_2/Vg1 opamp_2/Vd9 GND sky130_fd_pr__nfet_g5v0d10v5 ad=0 pd=0 as=0 ps=0 w=14.3 l=2
X469 opamp_2/Vd9 opamp_2/Vg1 opamp_2/Vg28 GND sky130_fd_pr__nfet_g5v0d10v5 ad=0 pd=0 as=0 ps=0 w=14.3 l=2
X470 opamp_2/Vg28 opamp_2/Vg1 opamp_2/Vd9 GND sky130_fd_pr__nfet_g5v0d10v5 ad=0 pd=0 as=0 ps=0 w=14.3 l=2
X471 GND opamp_2/Vg1 opamp_2/Vd9 GND sky130_fd_pr__nfet_g5v0d10v5 ad=0 pd=0 as=0 ps=0 w=10 l=5
X472 opamp_2/m25_26_0/m1_160_1028# opamp_2/m25_26_0/m1_160_1028# GND GND sky130_fd_pr__nfet_g5v0d10v5 ad=8.7 pd=63.48 as=0 ps=0 w=5 l=0.5
X473 opamp_2/m25_26_0/m1_160_1028# opamp_2/m25_26_0/m1_160_1028# GND GND sky130_fd_pr__nfet_g5v0d10v5 ad=0 pd=0 as=0 ps=0 w=5 l=0.5
X474 GND opamp_2/m25_26_0/m1_160_1028# opamp_2/m25_26_0/m1_160_1028# GND sky130_fd_pr__nfet_g5v0d10v5 ad=0 pd=0 as=0 ps=0 w=5 l=0.5
X475 GND opamp_2/m25_26_0/m1_160_1028# opamp_2/m25_26_0/m1_160_1028# GND sky130_fd_pr__nfet_g5v0d10v5 ad=0 pd=0 as=0 ps=0 w=5 l=0.5
X476 GND opamp_2/m25_26_0/m1_160_1028# opamp_2/m25_26_0/m1_160_1028# GND sky130_fd_pr__nfet_g5v0d10v5 ad=0 pd=0 as=0 ps=0 w=5 l=0.5
X477 opamp_2/Vd24 opamp_2/Vd24 opamp_2/m25_26_0/m1_160_1028# GND sky130_fd_pr__nfet_g5v0d10v5 ad=4.35 pd=31.74 as=0 ps=0 w=5 l=0.5
X478 opamp_2/Vd24 opamp_2/Vd24 opamp_2/m25_26_0/m1_160_1028# GND sky130_fd_pr__nfet_g5v0d10v5 ad=0 pd=0 as=0 ps=0 w=5 l=0.5
X479 opamp_2/m25_26_0/m1_160_1028# opamp_2/Vd24 opamp_2/Vd24 GND sky130_fd_pr__nfet_g5v0d10v5 ad=0 pd=0 as=0 ps=0 w=5 l=0.5
X480 opamp_2/m25_26_0/m1_160_1028# opamp_2/Vd24 opamp_2/Vd24 GND sky130_fd_pr__nfet_g5v0d10v5 ad=0 pd=0 as=0 ps=0 w=5 l=0.5
X481 opamp_2/m25_26_0/m1_160_1028# opamp_2/Vd24 opamp_2/Vd24 GND sky130_fd_pr__nfet_g5v0d10v5 ad=0 pd=0 as=0 ps=0 w=5 l=0.5
X482 opamp_2/Vg28 opamp_2/Vd24 opamp_2/Vg27 GND sky130_fd_pr__nfet_g5v0d10v5 ad=0 pd=0 as=8.7 ps=61.74 w=10 l=0.5
X483 opamp_2/Vg28 opamp_2/Vd24 opamp_2/Vg27 GND sky130_fd_pr__nfet_g5v0d10v5 ad=0 pd=0 as=0 ps=0 w=10 l=0.5
X484 opamp_2/Vg28 opamp_2/Vd24 opamp_2/Vg27 GND sky130_fd_pr__nfet_g5v0d10v5 ad=0 pd=0 as=0 ps=0 w=10 l=0.5
X485 opamp_2/Vg27 opamp_2/Vd24 opamp_2/Vg28 GND sky130_fd_pr__nfet_g5v0d10v5 ad=0 pd=0 as=0 ps=0 w=10 l=0.5
X486 opamp_2/Vg27 opamp_2/Vd24 opamp_2/Vg28 GND sky130_fd_pr__nfet_g5v0d10v5 ad=0 pd=0 as=0 ps=0 w=10 l=0.5
X487 opamp_2/Vg11 opamp_2/Vg11 opamp_2/Vd30 VDD sky130_fd_pr__pfet_g5v0d10v5 ad=8.7 pd=61.74 as=17.4 ps=123.48 w=10 l=1
X488 opamp_2/Vd30 opamp_2/Vg11 opamp_2/Vg11 VDD sky130_fd_pr__pfet_g5v0d10v5 ad=0 pd=0 as=0 ps=0 w=10 l=1
X489 opamp_2/Vd30 opamp_2/Vg11 opamp_2/Vg11 VDD sky130_fd_pr__pfet_g5v0d10v5 ad=0 pd=0 as=0 ps=0 w=10 l=1
X490 opamp_2/Vg11 opamp_2/Vg11 opamp_2/Vd30 VDD sky130_fd_pr__pfet_g5v0d10v5 ad=0 pd=0 as=0 ps=0 w=10 l=1
X491 opamp_2/Vg11 opamp_2/Vg11 opamp_2/Vd30 VDD sky130_fd_pr__pfet_g5v0d10v5 ad=0 pd=0 as=0 ps=0 w=10 l=1
X492 opamp_2/Vd30 opamp_2/Vg11 VDD VDD sky130_fd_pr__pfet_g5v0d10v5 ad=0 pd=0 as=0 ps=0 w=10 l=2.5
X493 VDD opamp_2/Vg11 opamp_2/Vd30 VDD sky130_fd_pr__pfet_g5v0d10v5 ad=0 pd=0 as=0 ps=0 w=10 l=2.5
X494 VDD opamp_2/Vg11 opamp_2/Vd30 VDD sky130_fd_pr__pfet_g5v0d10v5 ad=0 pd=0 as=0 ps=0 w=10 l=2.5
X495 opamp_2/Vd30 opamp_2/Vg11 VDD VDD sky130_fd_pr__pfet_g5v0d10v5 ad=0 pd=0 as=0 ps=0 w=10 l=2.5
X496 opamp_2/Vd30 opamp_2/Vg11 VDD VDD sky130_fd_pr__pfet_g5v0d10v5 ad=0 pd=0 as=0 ps=0 w=10 l=2.5
X497 opamp_2/Vg27 Vout3 sky130_fd_pr__cap_mim_m3_1 l=20 w=30
X498 opamp_2/Vg27 Vout3 sky130_fd_pr__cap_mim_m3_1 l=20 w=30
X499 opamp_2/Vg27 Vout3 sky130_fd_pr__cap_mim_m3_1 l=20 w=30
X500 opamp_2/Vg27 Vout3 sky130_fd_pr__cap_mim_m3_1 l=20 w=30
X501 opamp_2/Vg28 Vout3 sky130_fd_pr__cap_mim_m3_1 l=20 w=30
X502 opamp_2/Vg28 Vout3 sky130_fd_pr__cap_mim_m3_1 l=20 w=30
X503 opamp_2/Vg28 Vout3 sky130_fd_pr__cap_mim_m3_1 l=20 w=30
X504 opamp_2/Vg28 Vout3 sky130_fd_pr__cap_mim_m3_1 l=20 w=30
X505 opamp_2/Vg1 opamp_2/Vg1 opamp_2/m01_02/sky130_fd_pr__nfet_g5v0d10v5_Y3KDPX_0/D GND sky130_fd_pr__nfet_g5v0d10v5 ad=1.9314 pd=14.48 as=3.3814 ps=25.06 w=3.33 l=2
X506 opamp_2/m01_02/sky130_fd_pr__nfet_g5v0d10v5_Y3KDPX_0/D opamp_2/Vg1 opamp_2/Vg1 GND sky130_fd_pr__nfet_g5v0d10v5 ad=0 pd=0 as=0 ps=0 w=3.33 l=2
X507 opamp_2/m01_02/sky130_fd_pr__nfet_g5v0d10v5_Y3KDPX_0/D opamp_2/Vg1 opamp_2/Vg1 GND sky130_fd_pr__nfet_g5v0d10v5 ad=0 pd=0 as=0 ps=0 w=3.33 l=2
X508 GND opamp_2/Vg1 opamp_2/m01_02/sky130_fd_pr__nfet_g5v0d10v5_Y3KDPX_0/D GND sky130_fd_pr__nfet_g5v0d10v5 ad=0 pd=0 as=0 ps=0 w=5 l=5
X509 Vout3 opamp_2/Vg28 GND GND sky130_fd_pr__nfet_g5v0d10v5 ad=23.2 pd=164.64 as=0 ps=0 w=10 l=0.5
X510 Vout3 opamp_2/Vg28 GND GND sky130_fd_pr__nfet_g5v0d10v5 ad=0 pd=0 as=0 ps=0 w=10 l=0.5
X511 GND opamp_2/Vg28 Vout3 GND sky130_fd_pr__nfet_g5v0d10v5 ad=0 pd=0 as=0 ps=0 w=10 l=0.5
X512 Vout3 opamp_2/Vg28 GND GND sky130_fd_pr__nfet_g5v0d10v5 ad=0 pd=0 as=0 ps=0 w=10 l=0.5
X513 Vout3 opamp_2/Vg28 GND GND sky130_fd_pr__nfet_g5v0d10v5 ad=0 pd=0 as=0 ps=0 w=10 l=0.5
X514 Vout3 opamp_2/Vg28 GND GND sky130_fd_pr__nfet_g5v0d10v5 ad=0 pd=0 as=0 ps=0 w=10 l=0.5
X515 GND opamp_2/Vg28 Vout3 GND sky130_fd_pr__nfet_g5v0d10v5 ad=0 pd=0 as=0 ps=0 w=10 l=0.5
X516 Vout3 opamp_2/Vg28 GND GND sky130_fd_pr__nfet_g5v0d10v5 ad=0 pd=0 as=0 ps=0 w=10 l=0.5
X517 GND opamp_2/Vg28 Vout3 GND sky130_fd_pr__nfet_g5v0d10v5 ad=0 pd=0 as=0 ps=0 w=10 l=0.5
X518 GND opamp_2/Vg28 Vout3 GND sky130_fd_pr__nfet_g5v0d10v5 ad=0 pd=0 as=0 ps=0 w=10 l=0.5
X519 GND opamp_2/Vg28 Vout3 GND sky130_fd_pr__nfet_g5v0d10v5 ad=0 pd=0 as=0 ps=0 w=10 l=0.5
X520 GND opamp_2/Vg28 Vout3 GND sky130_fd_pr__nfet_g5v0d10v5 ad=0 pd=0 as=0 ps=0 w=10 l=0.5
X521 GND opamp_2/Vg28 Vout3 GND sky130_fd_pr__nfet_g5v0d10v5 ad=0 pd=0 as=0 ps=0 w=10 l=0.5
X522 GND opamp_2/Vg28 Vout3 GND sky130_fd_pr__nfet_g5v0d10v5 ad=0 pd=0 as=0 ps=0 w=10 l=0.5
X523 Vout3 opamp_2/Vg28 GND GND sky130_fd_pr__nfet_g5v0d10v5 ad=0 pd=0 as=0 ps=0 w=10 l=0.5
X524 opamp_2/Vs29 Vp opamp_2/Vd29 GND sky130_fd_pr__nfet_g5v0d10v5 ad=0 pd=0 as=16.1095 ps=114 w=11.11 l=1.5
X525 opamp_2/Vs29 Vp opamp_2/Vd29 GND sky130_fd_pr__nfet_g5v0d10v5 ad=0 pd=0 as=0 ps=0 w=11.11 l=1.5
X526 opamp_2/Vs29 Vp opamp_2/Vd29 GND sky130_fd_pr__nfet_g5v0d10v5 ad=0 pd=0 as=0 ps=0 w=11.11 l=1.5
X527 opamp_2/Vd29 Vp opamp_2/Vs29 GND sky130_fd_pr__nfet_g5v0d10v5 ad=0 pd=0 as=0 ps=0 w=11.11 l=1.5
X528 opamp_2/Vd29 Vp opamp_2/Vs29 GND sky130_fd_pr__nfet_g5v0d10v5 ad=0 pd=0 as=0 ps=0 w=11.11 l=1.5
X529 opamp_2/Vd29 Vp opamp_2/Vs29 GND sky130_fd_pr__nfet_g5v0d10v5 ad=0 pd=0 as=0 ps=0 w=11.11 l=1.5
X530 opamp_2/Vd29 Vp opamp_2/Vs29 GND sky130_fd_pr__nfet_g5v0d10v5 ad=0 pd=0 as=0 ps=0 w=11.11 l=1.5
X531 opamp_2/Vs29 Vp opamp_2/Vd29 GND sky130_fd_pr__nfet_g5v0d10v5 ad=0 pd=0 as=0 ps=0 w=11.11 l=1.5
X532 opamp_2/Vs29 Vp opamp_2/Vd29 GND sky130_fd_pr__nfet_g5v0d10v5 ad=0 pd=0 as=0 ps=0 w=11.11 l=1.5
X533 opamp_2/Vs29 Rgp opamp_2/Vd30 GND sky130_fd_pr__nfet_g5v0d10v5 ad=0 pd=0 as=16.1095 ps=114 w=11.11 l=1.5
X534 opamp_2/Vs29 Rgp opamp_2/Vd30 GND sky130_fd_pr__nfet_g5v0d10v5 ad=0 pd=0 as=0 ps=0 w=11.11 l=1.5
X535 opamp_2/Vs29 Rgp opamp_2/Vd30 GND sky130_fd_pr__nfet_g5v0d10v5 ad=0 pd=0 as=0 ps=0 w=11.11 l=1.5
X536 opamp_2/Vd30 Rgp opamp_2/Vs29 GND sky130_fd_pr__nfet_g5v0d10v5 ad=0 pd=0 as=0 ps=0 w=11.11 l=1.5
X537 opamp_2/Vd30 Rgp opamp_2/Vs29 GND sky130_fd_pr__nfet_g5v0d10v5 ad=0 pd=0 as=0 ps=0 w=11.11 l=1.5
X538 opamp_2/Vd30 Rgp opamp_2/Vs29 GND sky130_fd_pr__nfet_g5v0d10v5 ad=0 pd=0 as=0 ps=0 w=11.11 l=1.5
X539 opamp_2/Vd30 Rgp opamp_2/Vs29 GND sky130_fd_pr__nfet_g5v0d10v5 ad=0 pd=0 as=0 ps=0 w=11.11 l=1.5
X540 opamp_2/Vs29 Rgp opamp_2/Vd30 GND sky130_fd_pr__nfet_g5v0d10v5 ad=0 pd=0 as=0 ps=0 w=11.11 l=1.5
X541 opamp_2/Vs29 Rgp opamp_2/Vd30 GND sky130_fd_pr__nfet_g5v0d10v5 ad=0 pd=0 as=0 ps=0 w=11.11 l=1.5
X542 VDD opamp_2/m21_22_0/G opamp_2/m21_22_0/G VDD sky130_fd_pr__pfet_g5v0d10v5 ad=0 pd=0 as=26.1 ps=183.48 w=15 l=0.5
X543 VDD opamp_2/m21_22_0/G opamp_2/m21_22_0/G VDD sky130_fd_pr__pfet_g5v0d10v5 ad=0 pd=0 as=0 ps=0 w=15 l=0.5
X544 opamp_2/m21_22_0/G opamp_2/m21_22_0/G VDD VDD sky130_fd_pr__pfet_g5v0d10v5 ad=0 pd=0 as=0 ps=0 w=15 l=0.5
X545 VDD opamp_2/m21_22_0/G opamp_2/m21_22_0/G VDD sky130_fd_pr__pfet_g5v0d10v5 ad=0 pd=0 as=0 ps=0 w=15 l=0.5
X546 opamp_2/m21_22_0/G opamp_2/m21_22_0/G VDD VDD sky130_fd_pr__pfet_g5v0d10v5 ad=0 pd=0 as=0 ps=0 w=15 l=0.5
X547 opamp_2/m21_22_0/G opamp_2/Vg22 opamp_2/Vg22 VDD sky130_fd_pr__pfet_g5v0d10v5 ad=0 pd=0 as=13.05 ps=91.74 w=15 l=0.5
X548 opamp_2/m21_22_0/G opamp_2/Vg22 opamp_2/Vg22 VDD sky130_fd_pr__pfet_g5v0d10v5 ad=0 pd=0 as=0 ps=0 w=15 l=0.5
X549 opamp_2/Vg22 opamp_2/Vg22 opamp_2/m21_22_0/G VDD sky130_fd_pr__pfet_g5v0d10v5 ad=0 pd=0 as=0 ps=0 w=15 l=0.5
X550 opamp_2/m21_22_0/G opamp_2/Vg22 opamp_2/Vg22 VDD sky130_fd_pr__pfet_g5v0d10v5 ad=0 pd=0 as=0 ps=0 w=15 l=0.5
X551 opamp_2/Vg22 opamp_2/Vg22 opamp_2/m21_22_0/G VDD sky130_fd_pr__pfet_g5v0d10v5 ad=0 pd=0 as=0 ps=0 w=15 l=0.5
X552 opamp_2/Vg27 opamp_2/Vg22 opamp_2/Vg28 VDD sky130_fd_pr__pfet_g5v0d10v5 ad=0 pd=0 as=23.2 ps=164.64 w=10 l=0.5
X553 opamp_2/Vg27 opamp_2/Vg22 opamp_2/Vg28 VDD sky130_fd_pr__pfet_g5v0d10v5 ad=0 pd=0 as=0 ps=0 w=10 l=0.5
X554 opamp_2/Vg27 opamp_2/Vg22 opamp_2/Vg28 VDD sky130_fd_pr__pfet_g5v0d10v5 ad=0 pd=0 as=0 ps=0 w=10 l=0.5
X555 opamp_2/Vg28 opamp_2/Vg22 opamp_2/Vg27 VDD sky130_fd_pr__pfet_g5v0d10v5 ad=0 pd=0 as=0 ps=0 w=10 l=0.5
X556 opamp_2/Vg27 opamp_2/Vg22 opamp_2/Vg28 VDD sky130_fd_pr__pfet_g5v0d10v5 ad=0 pd=0 as=0 ps=0 w=10 l=0.5
X557 opamp_2/Vg27 opamp_2/Vg22 opamp_2/Vg28 VDD sky130_fd_pr__pfet_g5v0d10v5 ad=0 pd=0 as=0 ps=0 w=10 l=0.5
X558 opamp_2/Vg27 opamp_2/Vg22 opamp_2/Vg28 VDD sky130_fd_pr__pfet_g5v0d10v5 ad=0 pd=0 as=0 ps=0 w=10 l=0.5
X559 opamp_2/Vg28 opamp_2/Vg22 opamp_2/Vg27 VDD sky130_fd_pr__pfet_g5v0d10v5 ad=0 pd=0 as=0 ps=0 w=10 l=0.5
X560 opamp_2/Vg27 opamp_2/Vg22 opamp_2/Vg28 VDD sky130_fd_pr__pfet_g5v0d10v5 ad=0 pd=0 as=0 ps=0 w=10 l=0.5
X561 opamp_2/Vg28 opamp_2/Vg22 opamp_2/Vg27 VDD sky130_fd_pr__pfet_g5v0d10v5 ad=0 pd=0 as=0 ps=0 w=10 l=0.5
X562 opamp_2/Vg28 opamp_2/Vg22 opamp_2/Vg27 VDD sky130_fd_pr__pfet_g5v0d10v5 ad=0 pd=0 as=0 ps=0 w=10 l=0.5
X563 opamp_2/Vg28 opamp_2/Vg22 opamp_2/Vg27 VDD sky130_fd_pr__pfet_g5v0d10v5 ad=0 pd=0 as=0 ps=0 w=10 l=0.5
X564 opamp_2/Vg28 opamp_2/Vg22 opamp_2/Vg27 VDD sky130_fd_pr__pfet_g5v0d10v5 ad=0 pd=0 as=0 ps=0 w=10 l=0.5
X565 opamp_2/Vg28 opamp_2/Vg22 opamp_2/Vg27 VDD sky130_fd_pr__pfet_g5v0d10v5 ad=0 pd=0 as=0 ps=0 w=10 l=0.5
X566 opamp_2/Vg28 opamp_2/Vg22 opamp_2/Vg27 VDD sky130_fd_pr__pfet_g5v0d10v5 ad=0 pd=0 as=0 ps=0 w=10 l=0.5
X567 opamp_2/m5_m6_0/m1_4014_7500# opamp_2/Vg5 VDD VDD sky130_fd_pr__pfet_g5v0d10v5 ad=6.728 pd=48.72 as=0 ps=0 w=5 l=5
X568 VDD opamp_2/Vg5 opamp_2/m5_m6_0/m1_4014_7500# VDD sky130_fd_pr__pfet_g5v0d10v5 ad=0 pd=0 as=0 ps=0 w=5 l=5
X569 opamp_2/m5_m6_0/m1_4014_7500# opamp_2/Vg5 VDD VDD sky130_fd_pr__pfet_g5v0d10v5 ad=0 pd=0 as=0 ps=0 w=5 l=5
X570 opamp_2/m5_m6_0/m1_4014_7500# opamp_2/Vg5 opamp_2/Vg5 VDD sky130_fd_pr__pfet_g5v0d10v5 ad=0 pd=0 as=3.828 ps=27.56 w=6.6 l=2
X571 opamp_2/Vg5 opamp_2/Vg5 opamp_2/m5_m6_0/m1_4014_7500# VDD sky130_fd_pr__pfet_g5v0d10v5 ad=0 pd=0 as=0 ps=0 w=6.6 l=2
X572 opamp_2/Vg5 opamp_2/Vg5 opamp_2/m5_m6_0/m1_4014_7500# VDD sky130_fd_pr__pfet_g5v0d10v5 ad=0 pd=0 as=0 ps=0 w=6.6 l=2
X573 bandgap_0/bandgap_m7_0/li_n2243_728# bandgap_0/Vg12 bandgap_0/bandgap_m7_0/li_n4358_1040# GND sky130_fd_pr__nfet_g5v0d10v5 ad=0.145 pd=1.58 as=0.145 ps=1.58 w=0.5 l=10
X574 bandgap_0/bandgap_m7_0/li_n2243_n546# bandgap_0/Vg12 bandgap_0/bandgap_m7_0/li_n4360_n232# GND sky130_fd_pr__nfet_g5v0d10v5 ad=0.145 pd=1.58 as=0.145 ps=1.58 w=0.5 l=10
X575 bandgap_0/bandgap_m7_0/li_n2243_n546# bandgap_0/Vg12 bandgap_0/bandgap_m7_0/li_n4362_n868# GND sky130_fd_pr__nfet_g5v0d10v5 ad=0.145 pd=1.58 as=0.145 ps=1.58 w=0.5 l=10
X576 bandgap_0/Vg12 bandgap_0/Vg12 bandgap_0/bandgap_m7_0/li_n4363_1674# GND sky130_fd_pr__nfet_g5v0d10v5 ad=0.145 pd=1.58 as=0.145 ps=1.58 w=0.5 l=10
X577 bandgap_0/bandgap_m7_0/li_n2243_728# bandgap_0/Vg12 bandgap_0/bandgap_m7_0/li_n4361_404# GND sky130_fd_pr__nfet_g5v0d10v5 ad=0.145 pd=1.58 as=0.145 ps=1.58 w=0.5 l=10
X578 bandgap_0/bandgap_m7_0/li_n2244_88# bandgap_0/Vg12 bandgap_0/bandgap_m7_0/li_n4360_n232# GND sky130_fd_pr__nfet_g5v0d10v5 ad=0.145 pd=1.58 as=0.145 ps=1.58 w=0.5 l=10
X579 bandgap_0/bandgap_m7_0/li_n2244_1360# bandgap_0/Vg12 bandgap_0/bandgap_m7_0/li_n4363_1674# GND sky130_fd_pr__nfet_g5v0d10v5 ad=0.145 pd=1.58 as=0.145 ps=1.58 w=0.5 l=10
X580 bandgap_0/bandgap_m7_0/li_n2244_88# bandgap_0/Vg12 bandgap_0/bandgap_m7_0/li_n4361_404# GND sky130_fd_pr__nfet_g5v0d10v5 ad=0.145 pd=1.58 as=0.145 ps=1.58 w=0.5 l=10
X581 bandgap_0/bandgap_m7_0/li_n2244_1360# bandgap_0/Vg12 bandgap_0/bandgap_m7_0/li_n4358_1040# GND sky130_fd_pr__nfet_g5v0d10v5 ad=0.145 pd=1.58 as=0.145 ps=1.58 w=0.5 l=10
X582 GND bandgap_0/Vg12 bandgap_0/bandgap_m7_0/li_n4362_n868# GND sky130_fd_pr__nfet_g5v0d10v5 ad=0.145 pd=1.58 as=0.145 ps=1.58 w=0.5 l=10
X583 GND GND bandgap_0/Ve1 sky130_fd_pr__pnp_05v5_W3p40L3p40
X584 GND GND bandgap_0/Ve1 sky130_fd_pr__pnp_05v5_W3p40L3p40
X585 GND GND bandgap_0/Ve1 sky130_fd_pr__pnp_05v5_W3p40L3p40
X586 GND GND bandgap_0/Ve1 sky130_fd_pr__pnp_05v5_W3p40L3p40
X587 GND GND bandgap_0/Ve1 sky130_fd_pr__pnp_05v5_W3p40L3p40
X588 GND GND bandgap_0/Ve1 sky130_fd_pr__pnp_05v5_W3p40L3p40
X589 GND GND bandgap_0/Ve1 sky130_fd_pr__pnp_05v5_W3p40L3p40
X590 GND GND bandgap_0/Ve1 sky130_fd_pr__pnp_05v5_W3p40L3p40
X591 GND GND bandgap_0/Ve1 sky130_fd_pr__pnp_05v5_W3p40L3p40
X592 GND GND bandgap_0/Ve1 sky130_fd_pr__pnp_05v5_W3p40L3p40
X593 GND GND bandgap_0/Ve1 sky130_fd_pr__pnp_05v5_W3p40L3p40
X594 GND GND bandgap_0/Ve1 sky130_fd_pr__pnp_05v5_W3p40L3p40
X595 GND GND bandgap_0/Vg2 sky130_fd_pr__pnp_05v5_W3p40L3p40
X596 GND GND bandgap_0/Ve1 sky130_fd_pr__pnp_05v5_W3p40L3p40
X597 GND GND bandgap_0/Ve1 sky130_fd_pr__pnp_05v5_W3p40L3p40
X598 GND GND bandgap_0/Ve1 sky130_fd_pr__pnp_05v5_W3p40L3p40
X599 GND GND bandgap_0/Ve1 sky130_fd_pr__pnp_05v5_W3p40L3p40
X600 GND GND bandgap_0/Ve1 sky130_fd_pr__pnp_05v5_W3p40L3p40
X601 GND GND bandgap_0/Ve1 sky130_fd_pr__pnp_05v5_W3p40L3p40
X602 GND GND bandgap_0/Ve1 sky130_fd_pr__pnp_05v5_W3p40L3p40
X603 GND GND bandgap_0/Ve1 sky130_fd_pr__pnp_05v5_W3p40L3p40
X604 GND GND bandgap_0/Ve1 sky130_fd_pr__pnp_05v5_W3p40L3p40
X605 GND GND bandgap_0/Ve1 sky130_fd_pr__pnp_05v5_W3p40L3p40
X606 GND GND bandgap_0/Ve1 sky130_fd_pr__pnp_05v5_W3p40L3p40
X607 GND GND bandgap_0/Ve1 sky130_fd_pr__pnp_05v5_W3p40L3p40
X608 GND bandgap_0/Vg3 bandgap_0/Vg3 GND sky130_fd_pr__nfet_g5v0d10v5 ad=1.16 pd=8.58 as=0.58 ps=4.29 w=4 l=1
X609 bandgap_0/Vg3 bandgap_0/Vg3 GND GND sky130_fd_pr__nfet_g5v0d10v5 ad=0.58 pd=4.29 as=0.58 ps=4.29 w=4 l=1
X610 GND bandgap_0/Vg3 bandgap_0/Vg3 GND sky130_fd_pr__nfet_g5v0d10v5 ad=0.58 pd=4.29 as=0.58 ps=4.29 w=4 l=1
X611 GND bandgap_0/Vg3 bandgap_0/Vg3 GND sky130_fd_pr__nfet_g5v0d10v5 ad=0.58 pd=4.29 as=1.16 ps=8.58 w=4 l=1
X612 bandgap_0/Vg3 bandgap_0/Vg3 GND GND sky130_fd_pr__nfet_g5v0d10v5 ad=0.58 pd=4.29 as=0.58 ps=4.29 w=4 l=1
X613 GND bandgap_0/Vg3 bandgap_0/Vg10 GND sky130_fd_pr__nfet_g5v0d10v5 ad=0 pd=0 as=3.48 ps=25.74 w=4 l=1
X614 bandgap_0/Vg10 bandgap_0/Vg3 GND GND sky130_fd_pr__nfet_g5v0d10v5 ad=0 pd=0 as=0 ps=0 w=4 l=1
X615 GND bandgap_0/Vg3 bandgap_0/Vg10 GND sky130_fd_pr__nfet_g5v0d10v5 ad=0 pd=0 as=0 ps=0 w=4 l=1
X616 GND bandgap_0/Vg3 bandgap_0/Vg10 GND sky130_fd_pr__nfet_g5v0d10v5 ad=0 pd=0 as=0 ps=0 w=4 l=1
X617 bandgap_0/Vg10 bandgap_0/Vg3 GND GND sky130_fd_pr__nfet_g5v0d10v5 ad=0 pd=0 as=0 ps=0 w=4 l=1
X618 GND bandgap_0/Vg10 bandgap_0/bandgap_m3_3/D GND sky130_fd_pr__nfet_g5v0d10v5 ad=0 pd=0 as=6.96 ps=51.48 w=4 l=1
X619 bandgap_0/bandgap_m3_3/D bandgap_0/Vg10 GND GND sky130_fd_pr__nfet_g5v0d10v5 ad=0 pd=0 as=0 ps=0 w=4 l=1
X620 GND bandgap_0/Vg10 bandgap_0/bandgap_m3_3/D GND sky130_fd_pr__nfet_g5v0d10v5 ad=0 pd=0 as=0 ps=0 w=4 l=1
X621 GND bandgap_0/Vg10 bandgap_0/bandgap_m3_3/D GND sky130_fd_pr__nfet_g5v0d10v5 ad=0 pd=0 as=0 ps=0 w=4 l=1
X622 bandgap_0/bandgap_m3_3/D bandgap_0/Vg10 GND GND sky130_fd_pr__nfet_g5v0d10v5 ad=0 pd=0 as=0 ps=0 w=4 l=1
X623 bandgap_0/sky130_fd_pr__pfet_g5v0d10v5_CEYAGG_0/S bandgap_0/Vg2 bandgap_0/Vg3 bandgap_0/sky130_fd_pr__pfet_g5v0d10v5_CEYAGG_0/S sky130_fd_pr__pfet_g5v0d10v5 ad=1.16 pd=8.58 as=0.58 ps=4.29 w=4 l=1
X624 bandgap_0/Vg3 bandgap_0/Vg2 bandgap_0/sky130_fd_pr__pfet_g5v0d10v5_CEYAGG_0/S bandgap_0/sky130_fd_pr__pfet_g5v0d10v5_CEYAGG_0/S sky130_fd_pr__pfet_g5v0d10v5 ad=0.58 pd=4.29 as=0.58 ps=4.29 w=4 l=1
X625 bandgap_0/sky130_fd_pr__pfet_g5v0d10v5_CEYAGG_0/S bandgap_0/Vg2 bandgap_0/Vg3 bandgap_0/sky130_fd_pr__pfet_g5v0d10v5_CEYAGG_0/S sky130_fd_pr__pfet_g5v0d10v5 ad=0.58 pd=4.29 as=0.58 ps=4.29 w=4 l=1
X626 bandgap_0/sky130_fd_pr__pfet_g5v0d10v5_CEYAGG_0/S bandgap_0/Vg2 bandgap_0/Vg3 bandgap_0/sky130_fd_pr__pfet_g5v0d10v5_CEYAGG_0/S sky130_fd_pr__pfet_g5v0d10v5 ad=0.58 pd=4.29 as=1.16 ps=8.58 w=4 l=1
X627 bandgap_0/Vg3 bandgap_0/Vg2 bandgap_0/sky130_fd_pr__pfet_g5v0d10v5_CEYAGG_0/S bandgap_0/sky130_fd_pr__pfet_g5v0d10v5_CEYAGG_0/S sky130_fd_pr__pfet_g5v0d10v5 ad=0.58 pd=4.29 as=0.58 ps=4.29 w=4 l=1
X628 bandgap_0/bandgap_m3_3/D Vref bandgap_0/Vg12 GND sky130_fd_pr__nfet_g5v0d10v5 ad=0 pd=0 as=3.625 ps=27.32 w=4 l=1
X629 bandgap_0/Vg12 Vref bandgap_0/bandgap_m3_3/D GND sky130_fd_pr__nfet_g5v0d10v5 ad=0 pd=0 as=0 ps=0 w=4 l=1
X630 bandgap_0/bandgap_m3_3/D Vref bandgap_0/Vg12 GND sky130_fd_pr__nfet_g5v0d10v5 ad=0 pd=0 as=0 ps=0 w=4 l=1
X631 bandgap_0/bandgap_m3_3/D Vref bandgap_0/Vg12 GND sky130_fd_pr__nfet_g5v0d10v5 ad=0 pd=0 as=0 ps=0 w=4 l=1
X632 bandgap_0/Vg12 Vref bandgap_0/bandgap_m3_3/D GND sky130_fd_pr__nfet_g5v0d10v5 ad=0 pd=0 as=0 ps=0 w=4 l=1
X633 bandgap_0/Vs5 Vref bandgap_0/Vg5 GND sky130_fd_pr__nfet_g5v0d10v5 ad=1.45 pd=10.58 as=1.45 ps=10.58 w=5 l=1
X634 bandgap_0/sky130_fd_pr__pfet_g5v0d10v5_CEYAGG_0/S bandgap_0/Vg1 bandgap_0/Vg10 bandgap_0/sky130_fd_pr__pfet_g5v0d10v5_CEYAGG_0/S sky130_fd_pr__pfet_g5v0d10v5 ad=7.25 pd=54.06 as=3.48 ps=25.74 w=4 l=1
X635 bandgap_0/Vg10 bandgap_0/Vg1 bandgap_0/sky130_fd_pr__pfet_g5v0d10v5_CEYAGG_0/S bandgap_0/sky130_fd_pr__pfet_g5v0d10v5_CEYAGG_0/S sky130_fd_pr__pfet_g5v0d10v5 ad=0 pd=0 as=0 ps=0 w=4 l=1
X636 bandgap_0/sky130_fd_pr__pfet_g5v0d10v5_CEYAGG_0/S bandgap_0/Vg1 bandgap_0/Vg10 bandgap_0/sky130_fd_pr__pfet_g5v0d10v5_CEYAGG_0/S sky130_fd_pr__pfet_g5v0d10v5 ad=0 pd=0 as=0 ps=0 w=4 l=1
X637 bandgap_0/sky130_fd_pr__pfet_g5v0d10v5_CEYAGG_0/S bandgap_0/Vg1 bandgap_0/Vg10 bandgap_0/sky130_fd_pr__pfet_g5v0d10v5_CEYAGG_0/S sky130_fd_pr__pfet_g5v0d10v5 ad=0 pd=0 as=0 ps=0 w=4 l=1
X638 bandgap_0/Vg10 bandgap_0/Vg1 bandgap_0/sky130_fd_pr__pfet_g5v0d10v5_CEYAGG_0/S bandgap_0/sky130_fd_pr__pfet_g5v0d10v5_CEYAGG_0/S sky130_fd_pr__pfet_g5v0d10v5 ad=0 pd=0 as=0 ps=0 w=4 l=1
X639 bandgap_0/Vg1 bandgap_0/Ve1 GND sky130_fd_pr__res_high_po_0p69 l=6.99
X640 bandgap_0/sky130_fd_pr__pfet_g5v0d10v5_CEYAGG_0/S bandgap_0/Vg5 VDD VDD sky130_fd_pr__pfet_g5v0d10v5 ad=0.29 pd=2.58 as=0.29 ps=2.58 w=1 l=1
X641 bandgap_0/Vg12 bandgap_0/Vg5 VDD VDD sky130_fd_pr__pfet_g5v0d10v5 ad=0.29 pd=2.58 as=0 ps=0 w=1 l=1
X642 Vref bandgap_0/Vg12 VDD VDD sky130_fd_pr__pfet_g5v0d10v5 ad=0.58 pd=4.29 as=1.16 ps=8.58 w=4 l=0.5
X643 Vref bandgap_0/Vg12 VDD VDD sky130_fd_pr__pfet_g5v0d10v5 ad=1.16 pd=8.58 as=0.58 ps=4.29 w=4 l=0.5
X644 Vref bandgap_0/Vg12 VDD VDD sky130_fd_pr__pfet_g5v0d10v5 ad=0.58 pd=4.29 as=0.58 ps=4.29 w=4 l=0.5
X645 VDD bandgap_0/Vg12 Vref VDD sky130_fd_pr__pfet_g5v0d10v5 ad=0.58 pd=4.29 as=0.58 ps=4.29 w=4 l=0.5
X646 VDD bandgap_0/Vg12 Vref VDD sky130_fd_pr__pfet_g5v0d10v5 ad=0.58 pd=4.29 as=0.58 ps=4.29 w=4 l=0.5
X647 bandgap_0/Vg5 bandgap_0/Vg5 VDD VDD sky130_fd_pr__pfet_g5v0d10v5 ad=0.29 pd=2.58 as=0 ps=0 w=1 l=1
X648 GND bandgap_0/Vs5 GND sky130_fd_pr__res_high_po_0p35 l=49.12
X649 Vref bandgap_0/Vg1 GND sky130_fd_pr__res_high_po_0p35 l=20.1
X650 Vref bandgap_0/Vg2 GND sky130_fd_pr__res_high_po_0p35 l=20.1
X651 opamp_3/Vg27 opamp_3/Vg11 opamp_3/Vd29 VDD sky130_fd_pr__pfet_g5v0d10v5 ad=31.9 pd=226.38 as=17.4 ps=123.48 w=10 l=1
X652 opamp_3/Vd29 opamp_3/Vg11 opamp_3/Vg27 VDD sky130_fd_pr__pfet_g5v0d10v5 ad=0 pd=0 as=0 ps=0 w=10 l=1
X653 opamp_3/Vd29 opamp_3/Vg11 opamp_3/Vg27 VDD sky130_fd_pr__pfet_g5v0d10v5 ad=0 pd=0 as=0 ps=0 w=10 l=1
X654 opamp_3/Vg27 opamp_3/Vg11 opamp_3/Vd29 VDD sky130_fd_pr__pfet_g5v0d10v5 ad=0 pd=0 as=0 ps=0 w=10 l=1
X655 opamp_3/Vg27 opamp_3/Vg11 opamp_3/Vd29 VDD sky130_fd_pr__pfet_g5v0d10v5 ad=0 pd=0 as=0 ps=0 w=10 l=1
X656 opamp_3/Vd29 opamp_3/Vg11 VDD VDD sky130_fd_pr__pfet_g5v0d10v5 ad=0 pd=0 as=0 ps=0 w=10 l=2.5
X657 VDD opamp_3/Vg11 opamp_3/Vd29 VDD sky130_fd_pr__pfet_g5v0d10v5 ad=0 pd=0 as=0 ps=0 w=10 l=2.5
X658 VDD opamp_3/Vg11 opamp_3/Vd29 VDD sky130_fd_pr__pfet_g5v0d10v5 ad=0 pd=0 as=0 ps=0 w=10 l=2.5
X659 opamp_3/Vd29 opamp_3/Vg11 VDD VDD sky130_fd_pr__pfet_g5v0d10v5 ad=0 pd=0 as=0 ps=0 w=10 l=2.5
X660 opamp_3/Vd29 opamp_3/Vg11 VDD VDD sky130_fd_pr__pfet_g5v0d10v5 ad=0 pd=0 as=0 ps=0 w=10 l=2.5
X661 GND opamp_3/Vg1 opamp_3/Vg22 GND sky130_fd_pr__nfet_g5v0d10v5 ad=0 pd=0 as=0.435 ps=3.58 w=1.5 l=5
X662 opamp_3/Vd24 opamp_3/Vg5 VDD VDD sky130_fd_pr__pfet_g5v0d10v5 ad=1.16 pd=8.58 as=0 ps=0 w=4 l=5
X663 opamp_3/m07_08_0/m1_29362_10250# opamp_3/Vg5 opamp_3/Vd8 VDD sky130_fd_pr__pfet_g5v0d10v5 ad=13.456 pd=95.12 as=72.094 ps=504.16 w=13.2 l=2
X664 opamp_3/Vd8 opamp_3/Vg5 opamp_3/m07_08_0/m1_29362_10250# VDD sky130_fd_pr__pfet_g5v0d10v5 ad=0 pd=0 as=0 ps=0 w=13.2 l=2
X665 opamp_3/Vd8 opamp_3/Vg5 opamp_3/m07_08_0/m1_29362_10250# VDD sky130_fd_pr__pfet_g5v0d10v5 ad=0 pd=0 as=0 ps=0 w=13.2 l=2
X666 VDD opamp_3/Vg5 opamp_3/m07_08_0/m1_29362_10250# VDD sky130_fd_pr__pfet_g5v0d10v5 ad=0 pd=0 as=0 ps=0 w=10 l=5
X667 opamp_3/m07_08_0/m1_29362_10250# opamp_3/Vg5 VDD VDD sky130_fd_pr__pfet_g5v0d10v5 ad=0 pd=0 as=0 ps=0 w=10 l=5
X668 opamp_3/m07_08_0/m1_29362_10250# opamp_3/Vg5 VDD VDD sky130_fd_pr__pfet_g5v0d10v5 ad=0 pd=0 as=0 ps=0 w=10 l=5
X669 opamp_3/Vd10 opamp_3/Vg1 opamp_3/Vg11 GND sky130_fd_pr__nfet_g5v0d10v5 ad=19.488 pd=137.3 as=16.588 ps=116.72 w=14.3 l=2
X670 opamp_3/Vd10 opamp_3/Vg1 opamp_3/Vg11 GND sky130_fd_pr__nfet_g5v0d10v5 ad=0 pd=0 as=0 ps=0 w=14.3 l=2
X671 opamp_3/Vg11 opamp_3/Vg1 opamp_3/Vd10 GND sky130_fd_pr__nfet_g5v0d10v5 ad=0 pd=0 as=0 ps=0 w=14.3 l=2
X672 opamp_3/Vd10 opamp_3/Vg1 opamp_3/Vg11 GND sky130_fd_pr__nfet_g5v0d10v5 ad=0 pd=0 as=0 ps=0 w=14.3 l=2
X673 opamp_3/Vg11 opamp_3/Vg1 opamp_3/Vd10 GND sky130_fd_pr__nfet_g5v0d10v5 ad=0 pd=0 as=0 ps=0 w=14.3 l=2
X674 opamp_3/Vd10 opamp_3/Vg1 opamp_3/Vg11 GND sky130_fd_pr__nfet_g5v0d10v5 ad=0 pd=0 as=0 ps=0 w=14.3 l=2
X675 opamp_3/Vg11 opamp_3/Vg1 opamp_3/Vd10 GND sky130_fd_pr__nfet_g5v0d10v5 ad=0 pd=0 as=0 ps=0 w=14.3 l=2
X676 GND opamp_3/Vg1 opamp_3/Vd10 GND sky130_fd_pr__nfet_g5v0d10v5 ad=0 pd=0 as=0 ps=0 w=10 l=5
X677 opamp_3/Vs29 opamp_3/Vg1 opamp_3/m31_32_0/m1_21854_12984# GND sky130_fd_pr__nfet_g5v0d10v5 ad=36.0818 pd=255.8 as=6.7628 ps=48.38 w=6.66 l=2
X678 opamp_3/m31_32_0/m1_21854_12984# opamp_3/Vg1 opamp_3/Vs29 GND sky130_fd_pr__nfet_g5v0d10v5 ad=0 pd=0 as=0 ps=0 w=6.66 l=2
X679 opamp_3/m31_32_0/m1_21854_12984# opamp_3/Vg1 opamp_3/Vs29 GND sky130_fd_pr__nfet_g5v0d10v5 ad=0 pd=0 as=0 ps=0 w=6.66 l=2
X680 GND opamp_3/Vg1 opamp_3/m31_32_0/m1_21854_12984# GND sky130_fd_pr__nfet_g5v0d10v5 ad=0 pd=0 as=0 ps=0 w=10 l=5
X681 opamp_3/Vd9 Vmid opamp_3/Vd8 opamp_3/Vd8 sky130_fd_pr__pfet_g5v0d10v5 ad=32.219 pd=225.10001 as=0 ps=0 w=22.22 l=1.5
X682 opamp_3/Vd9 Vmid opamp_3/Vd8 opamp_3/Vd8 sky130_fd_pr__pfet_g5v0d10v5 ad=0 pd=0 as=0 ps=0 w=22.22 l=1.5
X683 opamp_3/Vd9 Vmid opamp_3/Vd8 opamp_3/Vd8 sky130_fd_pr__pfet_g5v0d10v5 ad=0 pd=0 as=0 ps=0 w=22.22 l=1.5
X684 opamp_3/Vd9 Vmid opamp_3/Vd8 opamp_3/Vd8 sky130_fd_pr__pfet_g5v0d10v5 ad=0 pd=0 as=0 ps=0 w=22.22 l=1.5
X685 opamp_3/Vd9 Vmid opamp_3/Vd8 opamp_3/Vd8 sky130_fd_pr__pfet_g5v0d10v5 ad=0 pd=0 as=0 ps=0 w=22.22 l=1.5
X686 opamp_3/Vd8 Vmid opamp_3/Vd9 opamp_3/Vd8 sky130_fd_pr__pfet_g5v0d10v5 ad=0 pd=0 as=0 ps=0 w=22.22 l=1.5
X687 opamp_3/Vd8 Vmid opamp_3/Vd9 opamp_3/Vd8 sky130_fd_pr__pfet_g5v0d10v5 ad=0 pd=0 as=0 ps=0 w=22.22 l=1.5
X688 opamp_3/Vd8 Vmid opamp_3/Vd9 opamp_3/Vd8 sky130_fd_pr__pfet_g5v0d10v5 ad=0 pd=0 as=0 ps=0 w=22.22 l=1.5
X689 opamp_3/Vd8 Vmid opamp_3/Vd9 opamp_3/Vd8 sky130_fd_pr__pfet_g5v0d10v5 ad=0 pd=0 as=0 ps=0 w=22.22 l=1.5
X690 opamp_3/Vd10 Vout5 opamp_3/Vd8 opamp_3/Vd8 sky130_fd_pr__pfet_g5v0d10v5 ad=32.219 pd=225.10001 as=0 ps=0 w=22.22 l=1.5
X691 opamp_3/Vd10 Vout5 opamp_3/Vd8 opamp_3/Vd8 sky130_fd_pr__pfet_g5v0d10v5 ad=0 pd=0 as=0 ps=0 w=22.22 l=1.5
X692 opamp_3/Vd10 Vout5 opamp_3/Vd8 opamp_3/Vd8 sky130_fd_pr__pfet_g5v0d10v5 ad=0 pd=0 as=0 ps=0 w=22.22 l=1.5
X693 opamp_3/Vd10 Vout5 opamp_3/Vd8 opamp_3/Vd8 sky130_fd_pr__pfet_g5v0d10v5 ad=0 pd=0 as=0 ps=0 w=22.22 l=1.5
X694 opamp_3/Vd10 Vout5 opamp_3/Vd8 opamp_3/Vd8 sky130_fd_pr__pfet_g5v0d10v5 ad=0 pd=0 as=0 ps=0 w=22.22 l=1.5
X695 opamp_3/Vd8 Vout5 opamp_3/Vd10 opamp_3/Vd8 sky130_fd_pr__pfet_g5v0d10v5 ad=0 pd=0 as=0 ps=0 w=22.22 l=1.5
X696 opamp_3/Vd8 Vout5 opamp_3/Vd10 opamp_3/Vd8 sky130_fd_pr__pfet_g5v0d10v5 ad=0 pd=0 as=0 ps=0 w=22.22 l=1.5
X697 opamp_3/Vd8 Vout5 opamp_3/Vd10 opamp_3/Vd8 sky130_fd_pr__pfet_g5v0d10v5 ad=0 pd=0 as=0 ps=0 w=22.22 l=1.5
X698 opamp_3/Vd8 Vout5 opamp_3/Vd10 opamp_3/Vd8 sky130_fd_pr__pfet_g5v0d10v5 ad=0 pd=0 as=0 ps=0 w=22.22 l=1.5
X699 opamp_3/Vg5 opamp_3/Vg1 opamp_3/M03_04/sky130_fd_pr__nfet_g5v0d10v5_Y3KDPX_0/D GND sky130_fd_pr__nfet_g5v0d10v5 ad=1.9314 pd=14.48 as=3.3814 ps=25.06 w=3.33 l=2
X700 opamp_3/M03_04/sky130_fd_pr__nfet_g5v0d10v5_Y3KDPX_0/D opamp_3/Vg1 opamp_3/Vg5 GND sky130_fd_pr__nfet_g5v0d10v5 ad=0 pd=0 as=0 ps=0 w=3.33 l=2
X701 opamp_3/M03_04/sky130_fd_pr__nfet_g5v0d10v5_Y3KDPX_0/D opamp_3/Vg1 opamp_3/Vg5 GND sky130_fd_pr__nfet_g5v0d10v5 ad=0 pd=0 as=0 ps=0 w=3.33 l=2
X702 GND opamp_3/Vg1 opamp_3/M03_04/sky130_fd_pr__nfet_g5v0d10v5_Y3KDPX_0/D GND sky130_fd_pr__nfet_g5v0d10v5 ad=0 pd=0 as=0 ps=0 w=5 l=5
X703 Vout5 opamp_3/Vg27 VDD VDD sky130_fd_pr__pfet_g5v0d10v5 ad=56.55 pd=397.54001 as=0 ps=0 w=15 l=0.5
X704 Vout5 opamp_3/Vg27 VDD VDD sky130_fd_pr__pfet_g5v0d10v5 ad=0 pd=0 as=0 ps=0 w=15 l=0.5
X705 Vout5 opamp_3/Vg27 VDD VDD sky130_fd_pr__pfet_g5v0d10v5 ad=0 pd=0 as=0 ps=0 w=15 l=0.5
X706 VDD opamp_3/Vg27 Vout5 VDD sky130_fd_pr__pfet_g5v0d10v5 ad=0 pd=0 as=0 ps=0 w=15 l=0.5
X707 Vout5 opamp_3/Vg27 VDD VDD sky130_fd_pr__pfet_g5v0d10v5 ad=0 pd=0 as=0 ps=0 w=15 l=0.5
X708 VDD opamp_3/Vg27 Vout5 VDD sky130_fd_pr__pfet_g5v0d10v5 ad=0 pd=0 as=0 ps=0 w=15 l=0.5
X709 Vout5 opamp_3/Vg27 VDD VDD sky130_fd_pr__pfet_g5v0d10v5 ad=0 pd=0 as=0 ps=0 w=15 l=0.5
X710 Vout5 opamp_3/Vg27 VDD VDD sky130_fd_pr__pfet_g5v0d10v5 ad=0 pd=0 as=0 ps=0 w=15 l=0.5
X711 Vout5 opamp_3/Vg27 VDD VDD sky130_fd_pr__pfet_g5v0d10v5 ad=0 pd=0 as=0 ps=0 w=15 l=0.5
X712 VDD opamp_3/Vg27 Vout5 VDD sky130_fd_pr__pfet_g5v0d10v5 ad=0 pd=0 as=0 ps=0 w=15 l=0.5
X713 Vout5 opamp_3/Vg27 VDD VDD sky130_fd_pr__pfet_g5v0d10v5 ad=0 pd=0 as=0 ps=0 w=15 l=0.5
X714 VDD opamp_3/Vg27 Vout5 VDD sky130_fd_pr__pfet_g5v0d10v5 ad=0 pd=0 as=0 ps=0 w=15 l=0.5
X715 VDD opamp_3/Vg27 Vout5 VDD sky130_fd_pr__pfet_g5v0d10v5 ad=0 pd=0 as=0 ps=0 w=15 l=0.5
X716 Vout5 opamp_3/Vg27 VDD VDD sky130_fd_pr__pfet_g5v0d10v5 ad=0 pd=0 as=0 ps=0 w=15 l=0.5
X717 VDD opamp_3/Vg27 Vout5 VDD sky130_fd_pr__pfet_g5v0d10v5 ad=0 pd=0 as=0 ps=0 w=15 l=0.5
X718 VDD opamp_3/Vg27 Vout5 VDD sky130_fd_pr__pfet_g5v0d10v5 ad=0 pd=0 as=0 ps=0 w=15 l=0.5
X719 Vout5 opamp_3/Vg27 VDD VDD sky130_fd_pr__pfet_g5v0d10v5 ad=0 pd=0 as=0 ps=0 w=15 l=0.5
X720 VDD opamp_3/Vg27 Vout5 VDD sky130_fd_pr__pfet_g5v0d10v5 ad=0 pd=0 as=0 ps=0 w=15 l=0.5
X721 Vout5 opamp_3/Vg27 VDD VDD sky130_fd_pr__pfet_g5v0d10v5 ad=0 pd=0 as=0 ps=0 w=15 l=0.5
X722 VDD opamp_3/Vg27 Vout5 VDD sky130_fd_pr__pfet_g5v0d10v5 ad=0 pd=0 as=0 ps=0 w=15 l=0.5
X723 Vout5 opamp_3/Vg27 VDD VDD sky130_fd_pr__pfet_g5v0d10v5 ad=0 pd=0 as=0 ps=0 w=15 l=0.5
X724 VDD opamp_3/Vg27 Vout5 VDD sky130_fd_pr__pfet_g5v0d10v5 ad=0 pd=0 as=0 ps=0 w=15 l=0.5
X725 VDD opamp_3/Vg27 Vout5 VDD sky130_fd_pr__pfet_g5v0d10v5 ad=0 pd=0 as=0 ps=0 w=15 l=0.5
X726 Vout5 opamp_3/Vg27 VDD VDD sky130_fd_pr__pfet_g5v0d10v5 ad=0 pd=0 as=0 ps=0 w=15 l=0.5
X727 VDD opamp_3/Vg27 Vout5 VDD sky130_fd_pr__pfet_g5v0d10v5 ad=0 pd=0 as=0 ps=0 w=15 l=0.5
X728 GND Vref opamp_3/VgR2 GND sky130_fd_pr__nfet_g5v0d10v5 ad=0 pd=0 as=1.45 ps=10.58 w=5 l=8
X729 opamp_3/VgR2 opamp_3/VgR2 VDD VDD sky130_fd_pr__pfet_g5v0d10v5 ad=1.16 pd=8.58 as=0 ps=0 w=4 l=5
X730 opamp_3/Vg1 opamp_3/VgR2 VDD VDD sky130_fd_pr__pfet_g5v0d10v5 ad=1.16 pd=8.58 as=0 ps=0 w=4 l=5
X731 opamp_3/Vd9 opamp_3/Vg1 opamp_3/Vg28 GND sky130_fd_pr__nfet_g5v0d10v5 ad=19.488 pd=137.3 as=25.288 ps=178.46001 w=14.3 l=2
X732 opamp_3/Vd9 opamp_3/Vg1 opamp_3/Vg28 GND sky130_fd_pr__nfet_g5v0d10v5 ad=0 pd=0 as=0 ps=0 w=14.3 l=2
X733 opamp_3/Vg28 opamp_3/Vg1 opamp_3/Vd9 GND sky130_fd_pr__nfet_g5v0d10v5 ad=0 pd=0 as=0 ps=0 w=14.3 l=2
X734 opamp_3/Vd9 opamp_3/Vg1 opamp_3/Vg28 GND sky130_fd_pr__nfet_g5v0d10v5 ad=0 pd=0 as=0 ps=0 w=14.3 l=2
X735 opamp_3/Vg28 opamp_3/Vg1 opamp_3/Vd9 GND sky130_fd_pr__nfet_g5v0d10v5 ad=0 pd=0 as=0 ps=0 w=14.3 l=2
X736 opamp_3/Vd9 opamp_3/Vg1 opamp_3/Vg28 GND sky130_fd_pr__nfet_g5v0d10v5 ad=0 pd=0 as=0 ps=0 w=14.3 l=2
X737 opamp_3/Vg28 opamp_3/Vg1 opamp_3/Vd9 GND sky130_fd_pr__nfet_g5v0d10v5 ad=0 pd=0 as=0 ps=0 w=14.3 l=2
X738 GND opamp_3/Vg1 opamp_3/Vd9 GND sky130_fd_pr__nfet_g5v0d10v5 ad=0 pd=0 as=0 ps=0 w=10 l=5
X739 opamp_3/m25_26_0/m1_160_1028# opamp_3/m25_26_0/m1_160_1028# GND GND sky130_fd_pr__nfet_g5v0d10v5 ad=8.7 pd=63.48 as=0 ps=0 w=5 l=0.5
X740 opamp_3/m25_26_0/m1_160_1028# opamp_3/m25_26_0/m1_160_1028# GND GND sky130_fd_pr__nfet_g5v0d10v5 ad=0 pd=0 as=0 ps=0 w=5 l=0.5
X741 GND opamp_3/m25_26_0/m1_160_1028# opamp_3/m25_26_0/m1_160_1028# GND sky130_fd_pr__nfet_g5v0d10v5 ad=0 pd=0 as=0 ps=0 w=5 l=0.5
X742 GND opamp_3/m25_26_0/m1_160_1028# opamp_3/m25_26_0/m1_160_1028# GND sky130_fd_pr__nfet_g5v0d10v5 ad=0 pd=0 as=0 ps=0 w=5 l=0.5
X743 GND opamp_3/m25_26_0/m1_160_1028# opamp_3/m25_26_0/m1_160_1028# GND sky130_fd_pr__nfet_g5v0d10v5 ad=0 pd=0 as=0 ps=0 w=5 l=0.5
X744 opamp_3/Vd24 opamp_3/Vd24 opamp_3/m25_26_0/m1_160_1028# GND sky130_fd_pr__nfet_g5v0d10v5 ad=4.35 pd=31.74 as=0 ps=0 w=5 l=0.5
X745 opamp_3/Vd24 opamp_3/Vd24 opamp_3/m25_26_0/m1_160_1028# GND sky130_fd_pr__nfet_g5v0d10v5 ad=0 pd=0 as=0 ps=0 w=5 l=0.5
X746 opamp_3/m25_26_0/m1_160_1028# opamp_3/Vd24 opamp_3/Vd24 GND sky130_fd_pr__nfet_g5v0d10v5 ad=0 pd=0 as=0 ps=0 w=5 l=0.5
X747 opamp_3/m25_26_0/m1_160_1028# opamp_3/Vd24 opamp_3/Vd24 GND sky130_fd_pr__nfet_g5v0d10v5 ad=0 pd=0 as=0 ps=0 w=5 l=0.5
X748 opamp_3/m25_26_0/m1_160_1028# opamp_3/Vd24 opamp_3/Vd24 GND sky130_fd_pr__nfet_g5v0d10v5 ad=0 pd=0 as=0 ps=0 w=5 l=0.5
X749 opamp_3/Vg28 opamp_3/Vd24 opamp_3/Vg27 GND sky130_fd_pr__nfet_g5v0d10v5 ad=0 pd=0 as=8.7 ps=61.74 w=10 l=0.5
X750 opamp_3/Vg28 opamp_3/Vd24 opamp_3/Vg27 GND sky130_fd_pr__nfet_g5v0d10v5 ad=0 pd=0 as=0 ps=0 w=10 l=0.5
X751 opamp_3/Vg28 opamp_3/Vd24 opamp_3/Vg27 GND sky130_fd_pr__nfet_g5v0d10v5 ad=0 pd=0 as=0 ps=0 w=10 l=0.5
X752 opamp_3/Vg27 opamp_3/Vd24 opamp_3/Vg28 GND sky130_fd_pr__nfet_g5v0d10v5 ad=0 pd=0 as=0 ps=0 w=10 l=0.5
X753 opamp_3/Vg27 opamp_3/Vd24 opamp_3/Vg28 GND sky130_fd_pr__nfet_g5v0d10v5 ad=0 pd=0 as=0 ps=0 w=10 l=0.5
X754 opamp_3/Vg11 opamp_3/Vg11 opamp_3/Vd30 VDD sky130_fd_pr__pfet_g5v0d10v5 ad=8.7 pd=61.74 as=17.4 ps=123.48 w=10 l=1
X755 opamp_3/Vd30 opamp_3/Vg11 opamp_3/Vg11 VDD sky130_fd_pr__pfet_g5v0d10v5 ad=0 pd=0 as=0 ps=0 w=10 l=1
X756 opamp_3/Vd30 opamp_3/Vg11 opamp_3/Vg11 VDD sky130_fd_pr__pfet_g5v0d10v5 ad=0 pd=0 as=0 ps=0 w=10 l=1
X757 opamp_3/Vg11 opamp_3/Vg11 opamp_3/Vd30 VDD sky130_fd_pr__pfet_g5v0d10v5 ad=0 pd=0 as=0 ps=0 w=10 l=1
X758 opamp_3/Vg11 opamp_3/Vg11 opamp_3/Vd30 VDD sky130_fd_pr__pfet_g5v0d10v5 ad=0 pd=0 as=0 ps=0 w=10 l=1
X759 opamp_3/Vd30 opamp_3/Vg11 VDD VDD sky130_fd_pr__pfet_g5v0d10v5 ad=0 pd=0 as=0 ps=0 w=10 l=2.5
X760 VDD opamp_3/Vg11 opamp_3/Vd30 VDD sky130_fd_pr__pfet_g5v0d10v5 ad=0 pd=0 as=0 ps=0 w=10 l=2.5
X761 VDD opamp_3/Vg11 opamp_3/Vd30 VDD sky130_fd_pr__pfet_g5v0d10v5 ad=0 pd=0 as=0 ps=0 w=10 l=2.5
X762 opamp_3/Vd30 opamp_3/Vg11 VDD VDD sky130_fd_pr__pfet_g5v0d10v5 ad=0 pd=0 as=0 ps=0 w=10 l=2.5
X763 opamp_3/Vd30 opamp_3/Vg11 VDD VDD sky130_fd_pr__pfet_g5v0d10v5 ad=0 pd=0 as=0 ps=0 w=10 l=2.5
X764 opamp_3/Vg27 Vout5 sky130_fd_pr__cap_mim_m3_1 l=20 w=30
X765 opamp_3/Vg27 Vout5 sky130_fd_pr__cap_mim_m3_1 l=20 w=30
X766 opamp_3/Vg27 Vout5 sky130_fd_pr__cap_mim_m3_1 l=20 w=30
X767 opamp_3/Vg27 Vout5 sky130_fd_pr__cap_mim_m3_1 l=20 w=30
X768 opamp_3/Vg28 Vout5 sky130_fd_pr__cap_mim_m3_1 l=20 w=30
X769 opamp_3/Vg28 Vout5 sky130_fd_pr__cap_mim_m3_1 l=20 w=30
X770 opamp_3/Vg28 Vout5 sky130_fd_pr__cap_mim_m3_1 l=20 w=30
X771 opamp_3/Vg28 Vout5 sky130_fd_pr__cap_mim_m3_1 l=20 w=30
X772 opamp_3/Vg1 opamp_3/Vg1 opamp_3/m01_02/sky130_fd_pr__nfet_g5v0d10v5_Y3KDPX_0/D GND sky130_fd_pr__nfet_g5v0d10v5 ad=1.9314 pd=14.48 as=3.3814 ps=25.06 w=3.33 l=2
X773 opamp_3/m01_02/sky130_fd_pr__nfet_g5v0d10v5_Y3KDPX_0/D opamp_3/Vg1 opamp_3/Vg1 GND sky130_fd_pr__nfet_g5v0d10v5 ad=0 pd=0 as=0 ps=0 w=3.33 l=2
X774 opamp_3/m01_02/sky130_fd_pr__nfet_g5v0d10v5_Y3KDPX_0/D opamp_3/Vg1 opamp_3/Vg1 GND sky130_fd_pr__nfet_g5v0d10v5 ad=0 pd=0 as=0 ps=0 w=3.33 l=2
X775 GND opamp_3/Vg1 opamp_3/m01_02/sky130_fd_pr__nfet_g5v0d10v5_Y3KDPX_0/D GND sky130_fd_pr__nfet_g5v0d10v5 ad=0 pd=0 as=0 ps=0 w=5 l=5
X776 Vout5 opamp_3/Vg28 GND GND sky130_fd_pr__nfet_g5v0d10v5 ad=23.2 pd=164.64 as=0 ps=0 w=10 l=0.5
X777 Vout5 opamp_3/Vg28 GND GND sky130_fd_pr__nfet_g5v0d10v5 ad=0 pd=0 as=0 ps=0 w=10 l=0.5
X778 GND opamp_3/Vg28 Vout5 GND sky130_fd_pr__nfet_g5v0d10v5 ad=0 pd=0 as=0 ps=0 w=10 l=0.5
X779 Vout5 opamp_3/Vg28 GND GND sky130_fd_pr__nfet_g5v0d10v5 ad=0 pd=0 as=0 ps=0 w=10 l=0.5
X780 Vout5 opamp_3/Vg28 GND GND sky130_fd_pr__nfet_g5v0d10v5 ad=0 pd=0 as=0 ps=0 w=10 l=0.5
X781 Vout5 opamp_3/Vg28 GND GND sky130_fd_pr__nfet_g5v0d10v5 ad=0 pd=0 as=0 ps=0 w=10 l=0.5
X782 GND opamp_3/Vg28 Vout5 GND sky130_fd_pr__nfet_g5v0d10v5 ad=0 pd=0 as=0 ps=0 w=10 l=0.5
X783 Vout5 opamp_3/Vg28 GND GND sky130_fd_pr__nfet_g5v0d10v5 ad=0 pd=0 as=0 ps=0 w=10 l=0.5
X784 GND opamp_3/Vg28 Vout5 GND sky130_fd_pr__nfet_g5v0d10v5 ad=0 pd=0 as=0 ps=0 w=10 l=0.5
X785 GND opamp_3/Vg28 Vout5 GND sky130_fd_pr__nfet_g5v0d10v5 ad=0 pd=0 as=0 ps=0 w=10 l=0.5
X786 GND opamp_3/Vg28 Vout5 GND sky130_fd_pr__nfet_g5v0d10v5 ad=0 pd=0 as=0 ps=0 w=10 l=0.5
X787 GND opamp_3/Vg28 Vout5 GND sky130_fd_pr__nfet_g5v0d10v5 ad=0 pd=0 as=0 ps=0 w=10 l=0.5
X788 GND opamp_3/Vg28 Vout5 GND sky130_fd_pr__nfet_g5v0d10v5 ad=0 pd=0 as=0 ps=0 w=10 l=0.5
X789 GND opamp_3/Vg28 Vout5 GND sky130_fd_pr__nfet_g5v0d10v5 ad=0 pd=0 as=0 ps=0 w=10 l=0.5
X790 Vout5 opamp_3/Vg28 GND GND sky130_fd_pr__nfet_g5v0d10v5 ad=0 pd=0 as=0 ps=0 w=10 l=0.5
X791 opamp_3/Vs29 Vmid opamp_3/Vd29 GND sky130_fd_pr__nfet_g5v0d10v5 ad=0 pd=0 as=16.1095 ps=114 w=11.11 l=1.5
X792 opamp_3/Vs29 Vmid opamp_3/Vd29 GND sky130_fd_pr__nfet_g5v0d10v5 ad=0 pd=0 as=0 ps=0 w=11.11 l=1.5
X793 opamp_3/Vs29 Vmid opamp_3/Vd29 GND sky130_fd_pr__nfet_g5v0d10v5 ad=0 pd=0 as=0 ps=0 w=11.11 l=1.5
X794 opamp_3/Vd29 Vmid opamp_3/Vs29 GND sky130_fd_pr__nfet_g5v0d10v5 ad=0 pd=0 as=0 ps=0 w=11.11 l=1.5
X795 opamp_3/Vd29 Vmid opamp_3/Vs29 GND sky130_fd_pr__nfet_g5v0d10v5 ad=0 pd=0 as=0 ps=0 w=11.11 l=1.5
X796 opamp_3/Vd29 Vmid opamp_3/Vs29 GND sky130_fd_pr__nfet_g5v0d10v5 ad=0 pd=0 as=0 ps=0 w=11.11 l=1.5
X797 opamp_3/Vd29 Vmid opamp_3/Vs29 GND sky130_fd_pr__nfet_g5v0d10v5 ad=0 pd=0 as=0 ps=0 w=11.11 l=1.5
X798 opamp_3/Vs29 Vmid opamp_3/Vd29 GND sky130_fd_pr__nfet_g5v0d10v5 ad=0 pd=0 as=0 ps=0 w=11.11 l=1.5
X799 opamp_3/Vs29 Vmid opamp_3/Vd29 GND sky130_fd_pr__nfet_g5v0d10v5 ad=0 pd=0 as=0 ps=0 w=11.11 l=1.5
X800 opamp_3/Vs29 Vout5 opamp_3/Vd30 GND sky130_fd_pr__nfet_g5v0d10v5 ad=0 pd=0 as=16.1095 ps=114 w=11.11 l=1.5
X801 opamp_3/Vs29 Vout5 opamp_3/Vd30 GND sky130_fd_pr__nfet_g5v0d10v5 ad=0 pd=0 as=0 ps=0 w=11.11 l=1.5
X802 opamp_3/Vs29 Vout5 opamp_3/Vd30 GND sky130_fd_pr__nfet_g5v0d10v5 ad=0 pd=0 as=0 ps=0 w=11.11 l=1.5
X803 opamp_3/Vd30 Vout5 opamp_3/Vs29 GND sky130_fd_pr__nfet_g5v0d10v5 ad=0 pd=0 as=0 ps=0 w=11.11 l=1.5
X804 opamp_3/Vd30 Vout5 opamp_3/Vs29 GND sky130_fd_pr__nfet_g5v0d10v5 ad=0 pd=0 as=0 ps=0 w=11.11 l=1.5
X805 opamp_3/Vd30 Vout5 opamp_3/Vs29 GND sky130_fd_pr__nfet_g5v0d10v5 ad=0 pd=0 as=0 ps=0 w=11.11 l=1.5
X806 opamp_3/Vd30 Vout5 opamp_3/Vs29 GND sky130_fd_pr__nfet_g5v0d10v5 ad=0 pd=0 as=0 ps=0 w=11.11 l=1.5
X807 opamp_3/Vs29 Vout5 opamp_3/Vd30 GND sky130_fd_pr__nfet_g5v0d10v5 ad=0 pd=0 as=0 ps=0 w=11.11 l=1.5
X808 opamp_3/Vs29 Vout5 opamp_3/Vd30 GND sky130_fd_pr__nfet_g5v0d10v5 ad=0 pd=0 as=0 ps=0 w=11.11 l=1.5
X809 VDD opamp_3/m21_22_0/G opamp_3/m21_22_0/G VDD sky130_fd_pr__pfet_g5v0d10v5 ad=0 pd=0 as=26.1 ps=183.48 w=15 l=0.5
X810 VDD opamp_3/m21_22_0/G opamp_3/m21_22_0/G VDD sky130_fd_pr__pfet_g5v0d10v5 ad=0 pd=0 as=0 ps=0 w=15 l=0.5
X811 opamp_3/m21_22_0/G opamp_3/m21_22_0/G VDD VDD sky130_fd_pr__pfet_g5v0d10v5 ad=0 pd=0 as=0 ps=0 w=15 l=0.5
X812 VDD opamp_3/m21_22_0/G opamp_3/m21_22_0/G VDD sky130_fd_pr__pfet_g5v0d10v5 ad=0 pd=0 as=0 ps=0 w=15 l=0.5
X813 opamp_3/m21_22_0/G opamp_3/m21_22_0/G VDD VDD sky130_fd_pr__pfet_g5v0d10v5 ad=0 pd=0 as=0 ps=0 w=15 l=0.5
X814 opamp_3/m21_22_0/G opamp_3/Vg22 opamp_3/Vg22 VDD sky130_fd_pr__pfet_g5v0d10v5 ad=0 pd=0 as=13.05 ps=91.74 w=15 l=0.5
X815 opamp_3/m21_22_0/G opamp_3/Vg22 opamp_3/Vg22 VDD sky130_fd_pr__pfet_g5v0d10v5 ad=0 pd=0 as=0 ps=0 w=15 l=0.5
X816 opamp_3/Vg22 opamp_3/Vg22 opamp_3/m21_22_0/G VDD sky130_fd_pr__pfet_g5v0d10v5 ad=0 pd=0 as=0 ps=0 w=15 l=0.5
X817 opamp_3/m21_22_0/G opamp_3/Vg22 opamp_3/Vg22 VDD sky130_fd_pr__pfet_g5v0d10v5 ad=0 pd=0 as=0 ps=0 w=15 l=0.5
X818 opamp_3/Vg22 opamp_3/Vg22 opamp_3/m21_22_0/G VDD sky130_fd_pr__pfet_g5v0d10v5 ad=0 pd=0 as=0 ps=0 w=15 l=0.5
X819 opamp_3/Vg27 opamp_3/Vg22 opamp_3/Vg28 VDD sky130_fd_pr__pfet_g5v0d10v5 ad=0 pd=0 as=23.2 ps=164.64 w=10 l=0.5
X820 opamp_3/Vg27 opamp_3/Vg22 opamp_3/Vg28 VDD sky130_fd_pr__pfet_g5v0d10v5 ad=0 pd=0 as=0 ps=0 w=10 l=0.5
X821 opamp_3/Vg27 opamp_3/Vg22 opamp_3/Vg28 VDD sky130_fd_pr__pfet_g5v0d10v5 ad=0 pd=0 as=0 ps=0 w=10 l=0.5
X822 opamp_3/Vg28 opamp_3/Vg22 opamp_3/Vg27 VDD sky130_fd_pr__pfet_g5v0d10v5 ad=0 pd=0 as=0 ps=0 w=10 l=0.5
X823 opamp_3/Vg27 opamp_3/Vg22 opamp_3/Vg28 VDD sky130_fd_pr__pfet_g5v0d10v5 ad=0 pd=0 as=0 ps=0 w=10 l=0.5
X824 opamp_3/Vg27 opamp_3/Vg22 opamp_3/Vg28 VDD sky130_fd_pr__pfet_g5v0d10v5 ad=0 pd=0 as=0 ps=0 w=10 l=0.5
X825 opamp_3/Vg27 opamp_3/Vg22 opamp_3/Vg28 VDD sky130_fd_pr__pfet_g5v0d10v5 ad=0 pd=0 as=0 ps=0 w=10 l=0.5
X826 opamp_3/Vg28 opamp_3/Vg22 opamp_3/Vg27 VDD sky130_fd_pr__pfet_g5v0d10v5 ad=0 pd=0 as=0 ps=0 w=10 l=0.5
X827 opamp_3/Vg27 opamp_3/Vg22 opamp_3/Vg28 VDD sky130_fd_pr__pfet_g5v0d10v5 ad=0 pd=0 as=0 ps=0 w=10 l=0.5
X828 opamp_3/Vg28 opamp_3/Vg22 opamp_3/Vg27 VDD sky130_fd_pr__pfet_g5v0d10v5 ad=0 pd=0 as=0 ps=0 w=10 l=0.5
X829 opamp_3/Vg28 opamp_3/Vg22 opamp_3/Vg27 VDD sky130_fd_pr__pfet_g5v0d10v5 ad=0 pd=0 as=0 ps=0 w=10 l=0.5
X830 opamp_3/Vg28 opamp_3/Vg22 opamp_3/Vg27 VDD sky130_fd_pr__pfet_g5v0d10v5 ad=0 pd=0 as=0 ps=0 w=10 l=0.5
X831 opamp_3/Vg28 opamp_3/Vg22 opamp_3/Vg27 VDD sky130_fd_pr__pfet_g5v0d10v5 ad=0 pd=0 as=0 ps=0 w=10 l=0.5
X832 opamp_3/Vg28 opamp_3/Vg22 opamp_3/Vg27 VDD sky130_fd_pr__pfet_g5v0d10v5 ad=0 pd=0 as=0 ps=0 w=10 l=0.5
X833 opamp_3/Vg28 opamp_3/Vg22 opamp_3/Vg27 VDD sky130_fd_pr__pfet_g5v0d10v5 ad=0 pd=0 as=0 ps=0 w=10 l=0.5
X834 opamp_3/m5_m6_0/m1_4014_7500# opamp_3/Vg5 VDD VDD sky130_fd_pr__pfet_g5v0d10v5 ad=6.728 pd=48.72 as=0 ps=0 w=5 l=5
X835 VDD opamp_3/Vg5 opamp_3/m5_m6_0/m1_4014_7500# VDD sky130_fd_pr__pfet_g5v0d10v5 ad=0 pd=0 as=0 ps=0 w=5 l=5
X836 opamp_3/m5_m6_0/m1_4014_7500# opamp_3/Vg5 VDD VDD sky130_fd_pr__pfet_g5v0d10v5 ad=0 pd=0 as=0 ps=0 w=5 l=5
X837 opamp_3/m5_m6_0/m1_4014_7500# opamp_3/Vg5 opamp_3/Vg5 VDD sky130_fd_pr__pfet_g5v0d10v5 ad=0 pd=0 as=3.828 ps=27.56 w=6.6 l=2
X838 opamp_3/Vg5 opamp_3/Vg5 opamp_3/m5_m6_0/m1_4014_7500# VDD sky130_fd_pr__pfet_g5v0d10v5 ad=0 pd=0 as=0 ps=0 w=6.6 l=2
X839 opamp_3/Vg5 opamp_3/Vg5 opamp_3/m5_m6_0/m1_4014_7500# VDD sky130_fd_pr__pfet_g5v0d10v5 ad=0 pd=0 as=0 ps=0 w=6.6 l=2
C0 VDD opamp_0/Vg5 40.35803f
C1 opamp_3/Vg11 Vout5 14.60566f
C2 Vout opamp_0/Vd30 2.41002f
C3 Vp opamp_2/Vs29 9.9276f
C4 opamp_2/Vg11 opamp_2/Vd29 10.4469f
C5 opamp_1/Vg1 opamp_1/Vg28 10.30674f
C6 opamp_3/Vg5 opamp_3/m5_m6_0/m1_4014_7500# 5.58454f
C7 opamp_3/Vg27 opamp_3/Vg11 5.62894f
C8 opamp_0/Vd8 opamp_0/Vd10 6.33543f
C9 opamp_1/Vg22 Vout2 14.99031f
C10 Vout opamp_0/Vd29 10.50656f
C11 Vout3 opamp_2/Vd29 10.50656f
C12 bandgap_0/Vg2 bandgap_0/sky130_fd_pr__pfet_g5v0d10v5_CEYAGG_0/S 3.432f
C13 opamp_3/Vg22 VDD 16.76686f
C14 opamp_3/Vg1 Vout5 15.506f
C15 opamp_1/Vg22 opamp_1/m21_22_0/G 7.55308f
C16 VDD Vout 76.92433f
C17 opamp_3/Vd9 opamp_3/Vd8 6.56878f
C18 Vout opamp_0/Vg22 14.99031f
C19 Vp opamp_2/Vd9 19.13077f
C20 opamp_2/m31_32_0/m1_21854_12984# opamp_2/Vg1 3.06803f
C21 opamp_2/Vd10 opamp_2/Vg1 10.63076f
C22 VDD opamp_3/Vd29 9.85583f
C23 opamp_3/Vg28 opamp_3/Vd24 5.03054f
C24 opamp_1/Vg28 opamp_1/Vg27 7.81879f
C25 opamp_0/m21_22_0/G Vout 3.45718f
C26 Rgp opamp_2/Vd30 10.72187f
C27 Vref Vout3 2.29456f
C28 bandgap_0/Ve1 Vref 3.61638f
C29 opamp_3/Vg22 Vout5 14.99031f
C30 opamp_3/Vs29 Vout5 9.92975f
C31 opamp_2/Vg11 opamp_2/Vg1 9.42796f
C32 opamp_3/m5_m6_0/m1_4014_7500# VDD 2.18726f
C33 opamp_3/Vs29 Vmid 9.9276f
C34 opamp_1/Vd8 opamp_1/Vd10 6.3411f
C35 opamp_2/Vg5 opamp_2/m07_08_0/m1_29362_10250# 8.72513f
C36 opamp_2/Vg1 opamp_2/Vg28 10.30674f
C37 opamp_0/Vs29 Vp4 9.9276f
C38 opamp_3/Vg27 opamp_3/Vg22 12.71117f
C39 VDD opamp_0/Vg28 5.76171f
C40 opamp_3/Vd9 Vout5 6.88871f
C41 bandgap_0/Ve1 bandgap_0/Vg2 3.82682f
C42 opamp_3/Vd9 Vmid 20.12228f
C43 Vout3 opamp_2/Vg1 15.50469f
C44 opamp_0/Vg22 opamp_0/Vg28 13.1255f
C45 VDD opamp_1/Vd8 4.0362f
C46 VDD opamp_2/m07_08_0/m1_29362_10250# 3.2948f
C47 opamp_1/Vg22 opamp_1/Vg27 12.71117f
C48 opamp_3/Vd29 Vout5 11.01137f
C49 opamp_3/Vd29 Vmid 11.01479f
C50 opamp_0/Vd8 Vp4 26.6289f
C51 opamp_0/Vd8 VDD 4.03378f
C52 opamp_3/Vg5 opamp_3/Vd8 4.30638f
C53 VDD Rgp 3.42185f
C54 VDD opamp_2/Vg27 81.89848f
C55 opamp_1/m5_m6_0/m1_4014_7500# opamp_1/Vg5 5.58454f
C56 opamp_2/Vd24 opamp_2/Vg27 4.59631f
C57 opamp_2/Vd9 opamp_2/Vd8 6.57226f
C58 opamp_3/Vg5 VDD 41.58646f
C59 opamp_3/Vg28 VDD 5.76171f
C60 opamp_1/Vg22 opamp_1/Vg28 13.1255f
C61 opamp_3/Vg11 opamp_3/Vd30 11.10904f
C62 VDD opamp_1/Vg11 32.20789f
C63 opamp_0/Vg1 opamp_0/Vd9 12.26229f
C64 VDD opamp_0/m07_08_0/m1_29362_10250# 3.11738f
C65 VDD opamp_1/m07_08_0/m1_29362_10250# 3.11738f
C66 VDD opamp_0/Vd30 7.7221f
C67 VDD opamp_2/Vd30 7.86483f
C68 opamp_0/Vd9 Vout 6.73022f
C69 VDD bandgap_0/Vg5 7.12317f
C70 Vref bandgap_0/Vg12 6.37051f
C71 opamp_0/Vd24 opamp_0/m25_26_0/m1_160_1028# 2.78577f
C72 opamp_0/Vg27 opamp_0/Vg11 5.62894f
C73 opamp_3/Vg1 opamp_3/m31_32_0/m1_21854_12984# 3.06803f
C74 Vp4 opamp_0/Vd29 10.9124f
C75 Rgn opamp_1/Vd8 31.63265f
C76 opamp_3/Vg5 Vout5 11.94788f
C77 opamp_3/Vg28 Vout5 0.2412p
C78 opamp_0/Vg1 opamp_0/m31_32_0/m1_21854_12984# 3.06895f
C79 VDD opamp_0/Vd29 9.84027f
C80 opamp_3/Vg22 opamp_3/m21_22_0/G 7.55308f
C81 opamp_2/Vg22 opamp_2/Vg27 12.71117f
C82 VDD opamp_2/Vg5 43.85909f
C83 Vout3 opamp_2/Vd9 6.73843f
C84 Vout5 opamp_3/Vd24 8.73015f
C85 VDD opamp_0/m5_m6_0/m1_4014_7500# 2.05436f
C86 opamp_1/Vd24 opamp_1/m25_26_0/m1_160_1028# 2.78577f
C87 opamp_1/Vd8 Vn 25.93387f
C88 Rgp opamp_2/Vd8 26.19081f
C89 opamp_3/Vg27 opamp_3/Vg28 7.81883f
C90 opamp_2/m25_26_0/m1_160_1028# opamp_2/Vd24 2.78577f
C91 VDD opamp_3/Vd8 4.0464f
C92 opamp_2/Vd10 Rgp 18.32126f
C93 VDD Vp 2.94596f
C94 opamp_3/Vg27 opamp_3/Vd24 4.59631f
C95 VDD Vp4 6.26542f
C96 opamp_1/Vd8 opamp_1/Vd9 6.57598f
C97 opamp_3/Vg1 opamp_3/Vd10 10.63076f
C98 Vout2 opamp_1/Vg11 14.60185f
C99 opamp_2/m5_m6_0/m1_4014_7500# opamp_2/Vg5 5.58454f
C100 VDD opamp_0/Vg22 16.67966f
C101 opamp_2/Vg11 opamp_2/Vg27 5.62894f
C102 opamp_3/m07_08_0/m1_29362_10250# opamp_3/Vg5 8.72179f
C103 opamp_0/m21_22_0/G VDD 11.90247f
C104 opamp_0/Vd8 opamp_0/Vd9 6.57122f
C105 opamp_2/Vg28 opamp_2/Vg27 7.81858f
C106 VDD opamp_2/m5_m6_0/m1_4014_7500# 2.1812f
C107 opamp_0/m21_22_0/G opamp_0/Vg22 7.55308f
C108 opamp_3/m01_02/sky130_fd_pr__nfet_g5v0d10v5_Y3KDPX_0/D opamp_3/Vg1 2.04512f
C109 opamp_2/VgR2 VDD 7.32815f
C110 Rgn opamp_1/Vs29 9.92975f
C111 Vout5 opamp_3/Vd8 27.58975f
C112 opamp_1/Vg1 opamp_1/Vg11 9.42796f
C113 VDD opamp_0/VgR2 6.86667f
C114 VDD opamp_2/m21_22_0/G 12.04534f
C115 Vmid opamp_3/Vd8 27.44282f
C116 opamp_3/Vg11 opamp_3/Vg1 9.42796f
C117 Vout3 opamp_2/Vg27 0.25246p
C118 Vout opamp_0/Vg27 0.25262p
C119 Rgn opamp_1/Vd10 19.30688f
C120 VDD Vout5 90.04514f
C121 Vn opamp_1/Vs29 9.9276f
C122 VDD Vmid 10.34359f
C123 opamp_2/Vg5 opamp_2/Vd8 4.3033f
C124 opamp_2/Vg11 opamp_2/Vd30 11.10904f
C125 Vout2 opamp_1/Vd10 2.74436f
C126 opamp_1/Vd30 opamp_1/Vg11 11.10904f
C127 opamp_3/Vg27 VDD 80.99722f
C128 VDD opamp_2/Vg22 16.73745f
C129 Vp opamp_2/Vd8 26.11956f
C130 VDD opamp_3/VgR2 6.86667f
C131 opamp_1/Vd8 opamp_1/Vg5 4.28173f
C132 Rgn VDD 11.69341f
C133 opamp_1/Vg1 opamp_1/Vs29 2.19683f
C134 VDD opamp_2/Vd8 4.32843f
C135 opamp_2/m01_02/sky130_fd_pr__nfet_g5v0d10v5_Y3KDPX_0/D opamp_2/Vg1 2.04512f
C136 opamp_2/Vg1 opamp_2/Vs29 2.19683f
C137 VDD Vout2 85.91603f
C138 Vout3 opamp_2/Vd30 2.41002f
C139 opamp_1/Vd29 opamp_1/Vg11 10.4469f
C140 opamp_1/Vg1 opamp_1/Vd10 10.63076f
C141 opamp_0/Vd24 opamp_0/Vg27 4.59631f
C142 VDD Vn 2.17395f
C143 opamp_3/m07_08_0/m1_29362_10250# VDD 3.25535f
C144 opamp_2/m21_22_0/G opamp_2/Vg22 7.55308f
C145 opamp_0/Vg27 opamp_0/Vg28 7.81883f
C146 opamp_0/Vg1 opamp_0/Vg11 9.42796f
C147 VDD opamp_2/Vg11 32.39076f
C148 opamp_1/Vg11 opamp_1/Vg27 5.62894f
C149 opamp_3/Vg27 Vout5 0.25301p
C150 opamp_2/Vg5 Vout3 8.86845f
C151 Vout opamp_0/Vg11 14.60118f
C152 opamp_0/Vs29 Vn4 9.92975f
C153 VDD opamp_1/m21_22_0/G 11.90247f
C154 opamp_0/Vd10 Vn4 18.67064f
C155 opamp_0/Vd9 Vp4 19.13207f
C156 opamp_3/Vg11 opamp_3/Vd29 10.4469f
C157 opamp_1/m07_08_0/m1_29362_10250# opamp_1/Vg5 8.72513f
C158 VDD opamp_2/Vg28 6.0082f
C159 opamp_2/Vd24 opamp_2/Vg28 5.03054f
C160 opamp_0/Vg1 opamp_0/Vg5 2.03511f
C161 bandgap_0/sky130_fd_pr__pfet_g5v0d10v5_CEYAGG_0/S bandgap_0/Vg1 3.86422f
C162 VDD opamp_1/Vd30 7.7221f
C163 VDD Vout3 83.43378f
C164 opamp_3/Vs29 opamp_3/Vg1 2.19683f
C165 Vout opamp_0/Vg5 8.88129f
C166 opamp_0/Vd8 Vn4 28.37907f
C167 opamp_2/Vd24 Vout3 8.73015f
C168 opamp_2/Vd9 opamp_2/Vg1 12.26229f
C169 opamp_3/m25_26_0/m1_160_1028# opamp_3/Vd24 2.78577f
C170 opamp_1/Vd29 VDD 9.84027f
C171 VDD opamp_3/m21_22_0/G 12.03283f
C172 opamp_2/Vd10 opamp_2/Vd8 6.31189f
C173 Rgn Vn 3.46525f
C174 opamp_1/Vd24 Vout2 8.73015f
C175 opamp_3/Vg1 opamp_3/Vd9 12.26229f
C176 opamp_2/m21_22_0/G Vout3 3.45718f
C177 opamp_0/Vd30 Vn4 10.41878f
C178 VDD opamp_1/Vg5 40.51174f
C179 Vout2 opamp_1/Vd9 6.73022f
C180 VDD opamp_1/Vg27 53.23235f
C181 opamp_2/Vg22 opamp_2/Vg28 13.1255f
C182 Vn opamp_1/Vd9 19.12968f
C183 opamp_1/Vg1 Vout2 15.50469f
C184 opamp_0/Vg1 Vout 15.50469f
C185 opamp_1/m21_22_0/G Vout2 3.45718f
C186 opamp_2/Vg22 Vout3 14.99031f
C187 opamp_3/Vd30 VDD 7.79605f
C188 opamp_1/VgR2 VDD 6.86501f
C189 Vp opamp_2/Vd29 10.92988f
C190 opamp_3/m21_22_0/G Vout5 3.45718f
C191 Rgn opamp_1/Vd30 10.40867f
C192 opamp_3/Vd8 opamp_3/Vd10 6.34397f
C193 VDD opamp_2/Vd29 9.85321f
C194 opamp_1/Vg1 opamp_1/Vd9 12.26229f
C195 VDD opamp_1/Vg28 5.76309f
C196 opamp_1/Vd30 Vout2 2.41002f
C197 opamp_0/Vd8 opamp_0/Vg5 4.30638f
C198 VDD opamp_0/Vg27 53.15857f
C199 opamp_2/Vd10 Vout3 2.74436f
C200 opamp_0/Vg27 opamp_0/Vg22 12.71117f
C201 Vp4 Vn4 4.36806f
C202 opamp_1/m31_32_0/m1_21854_12984# opamp_1/Vg1 3.06803f
C203 VDD bandgap_0/Vg12 7.89174f
C204 Rgp opamp_2/Vs29 10.7192f
C205 opamp_0/Vd30 opamp_0/Vg11 11.10904f
C206 VDD Vn4 6.17669f
C207 opamp_1/Vd29 Vout2 10.50656f
C208 Vout opamp_0/Vd24 8.73015f
C209 opamp_3/Vg1 opamp_3/Vg5 2.03511f
C210 opamp_3/Vg28 opamp_3/Vg1 10.30674f
C211 opamp_2/Vg11 Vout3 14.60118f
C212 opamp_1/Vd29 Vn 10.93354f
C213 opamp_0/Vg1 opamp_0/Vs29 2.19683f
C214 opamp_0/Vg1 opamp_0/Vd10 10.63076f
C215 opamp_3/Vd30 Vout5 12.95551f
C216 opamp_0/Vg1 opamp_0/Vg28 10.30674f
C217 opamp_1/Vg1 opamp_1/m01_02/sky130_fd_pr__nfet_g5v0d10v5_Y3KDPX_0/D 2.04512f
C218 opamp_0/Vg5 opamp_0/m07_08_0/m1_29362_10250# 8.72513f
C219 opamp_0/Vd10 Vout 2.74436f
C220 Vout3 opamp_2/Vg28 0.24129p
C221 opamp_0/Vg11 opamp_0/Vd29 10.4469f
C222 VDD opamp_1/Vg22 16.67966f
C223 Vout2 opamp_1/Vg5 8.90882f
C224 Vout opamp_0/Vg28 0.24108p
C225 Vout2 opamp_1/Vg27 0.25281p
C226 opamp_1/Vd24 opamp_1/Vg27 4.59631f
C227 opamp_3/Vg11 VDD 32.40379f
C228 Vout5 opamp_3/Vd10 22.08344f
C229 VDD Vref 28.04626f
C230 VDD opamp_1/m5_m6_0/m1_4014_7500# 2.05436f
C231 opamp_2/Vg5 opamp_2/Vg1 2.03511f
C232 opamp_3/Vg22 opamp_3/Vg28 13.1255f
C233 opamp_0/Vg1 opamp_0/m01_02/sky130_fd_pr__nfet_g5v0d10v5_Y3KDPX_0/D 2.04512f
C234 VDD opamp_0/Vg11 32.20789f
C235 opamp_1/Vg1 opamp_1/Vg5 2.03511f
C236 opamp_0/Vg5 opamp_0/m5_m6_0/m1_4014_7500# 5.58454f
C237 Vout2 opamp_1/Vg28 0.24107p
C238 opamp_1/Vd24 opamp_1/Vg28 5.03054f
C239 opamp_0/Vd24 opamp_0/Vg28 5.03054f
C240 opamp_3/Vs29 GND 5.43116f **FLOATING
C241 Vmid GND 7.03491f
C242 opamp_3/Vg28 GND 42.08957f
C243 Vout5 GND 0.14595p
C244 opamp_3/Vd30 GND 3.04396f **FLOATING
C245 opamp_3/Vg11 GND 3.49389f **FLOATING
C246 opamp_3/m25_26_0/m1_160_1028# GND 5.13447f **FLOATING
C247 opamp_3/Vd24 GND 10.24053f
C248 opamp_3/Vd9 GND 15.6496f **FLOATING
C249 opamp_3/VgR2 GND 5.38253f
C250 opamp_3/Vg27 GND 13.59067f
C251 opamp_3/Vg1 GND 48.14874f
C252 opamp_3/Vg5 GND 5.57141f
C253 opamp_3/Vd8 GND 0.10902p **FLOATING
C254 opamp_3/Vd10 GND 10.1702f **FLOATING
C255 opamp_3/Vg22 GND 6.73139f
C256 opamp_3/Vd29 GND 3.89839f **FLOATING
C257 bandgap_0/Vg1 GND 2.05474f
C258 bandgap_0/sky130_fd_pr__pfet_g5v0d10v5_CEYAGG_0/S GND 13.16624f
C259 bandgap_0/bandgap_m3_3/D GND 2.48855f
C260 Vref GND 71.63693f
C261 bandgap_0/Vg2 GND 2.85657f
C262 bandgap_0/Vg10 GND 5.5189f
C263 bandgap_0/Vg3 GND 8.35142f
C264 bandgap_0/Ve1 GND 61.71934f
C265 bandgap_0/Vg12 GND 19.95356f
C266 opamp_2/Vs29 GND 5.43116f **FLOATING
C267 Rgp GND 15.12753f
C268 Vp GND 6.83845f
C269 opamp_2/Vg28 GND 41.91743f
C270 Vout3 GND 0.14383p
C271 opamp_2/Vd30 GND 3.04396f **FLOATING
C272 opamp_2/Vg11 GND 3.49389f **FLOATING
C273 opamp_2/m25_26_0/m1_160_1028# GND 5.13447f **FLOATING
C274 opamp_2/Vd24 GND 10.24053f
C275 opamp_2/Vd9 GND 15.65072f **FLOATING
C276 opamp_2/VgR2 GND 5.30489f
C277 opamp_2/Vg27 GND 13.59067f
C278 opamp_2/Vg1 GND 48.33762f
C279 opamp_2/Vg5 GND 5.51314f
C280 opamp_2/Vd8 GND 0.10902p **FLOATING
C281 opamp_2/Vd10 GND 10.16708f **FLOATING
C282 opamp_2/Vg22 GND 6.73139f
C283 opamp_2/Vd29 GND 3.89724f **FLOATING
C284 VDD GND 1.4168p
C285 opamp_1/Vs29 GND 5.43116f **FLOATING
C286 Rgn GND 9.33155f
C287 Vn GND 7.79703f
C288 opamp_1/Vg28 GND 42.46302f
C289 Vout2 GND 0.13933p
C290 opamp_1/Vd30 GND 3.04396f **FLOATING
C291 opamp_1/Vg11 GND 3.49389f **FLOATING
C292 opamp_1/m25_26_0/m1_160_1028# GND 5.13447f **FLOATING
C293 opamp_1/Vd24 GND 10.24053f
C294 opamp_1/Vd9 GND 16.01484f **FLOATING
C295 opamp_1/VgR2 GND 5.70928f
C296 opamp_1/Vg27 GND 14.03632f
C297 opamp_1/Vg1 GND 48.85492f
C298 opamp_1/Vg5 GND 6.02264f
C299 opamp_1/Vd8 GND 0.10952p **FLOATING
C300 opamp_1/Vd10 GND 10.16947f **FLOATING
C301 opamp_1/Vg22 GND 6.73139f
C302 opamp_1/Vd29 GND 3.89899f **FLOATING
C303 opamp_0/Vs29 GND 5.43116f **FLOATING
C304 Vn4 GND 11.49944f
C305 Vp4 GND 13.40468f
C306 opamp_0/Vg28 GND 41.51816f
C307 Vout GND 0.13525p
C308 opamp_0/Vd30 GND 3.04396f **FLOATING
C309 opamp_0/Vg11 GND 3.49389f **FLOATING
C310 opamp_0/m25_26_0/m1_160_1028# GND 5.13447f **FLOATING
C311 opamp_0/Vd24 GND 10.24053f
C312 opamp_0/Vd9 GND 15.70595f **FLOATING
C313 opamp_0/VgR2 GND 5.48661f
C314 opamp_0/Vg27 GND 13.59067f
C315 opamp_0/Vg1 GND 48.3787f
C316 opamp_0/Vg5 GND 6.32989f
C317 opamp_0/Vd8 GND 0.10913p **FLOATING
C318 opamp_0/Vd10 GND 10.16682f **FLOATING
C319 opamp_0/Vg22 GND 6.73139f
C320 opamp_0/Vd29 GND 3.89899f **FLOATING
